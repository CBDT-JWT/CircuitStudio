* Copyright 2022 GlobalFoundries PDK Authors
*
* Licensed under the Apache License, Version 2.0 (the "License");
* you may not use this file except in compliance with the License.
* You may obtain a copy of the License at
*
*     https://www.apache.org/licenses/LICENSE-2.0
*
* Unless required by applicable law or agreed to in writing, software
* distributed under the License is distributed on an "AS IS" BASIS,
* WITHOUT WARRANTIES OR CONDITIONS OF ANY KIND, either express or implied.
* See the License for the specific language governing permissions and
* limitations under the License.

*******************************************************************************
* CIRCUIT_STUDIO_GF180MCU_SF: exact upstream 3.3V BSIM4 cards.
* Coefficients unchanged; no SAB wrappers, statistical mismatch or signoff.
.param fnoicor=0
.param
 +nmos_3p3_noia='(fnoicor==0)*3.2e+041 + (fnoicor==1)*3.5e+042'
 +nmos_3p3_noib='(fnoicor==0)*1.2e+020 + (fnoicor==1)*1.2e+020'
 +nmos_3p3_noic='(fnoicor==0)*6.0e+008 + (fnoicor==1)*6.0e+008'
 +pmos_3p3_noia='(fnoicor==0)*3.2e+041 + (fnoicor==1)*4.0e+042'
 +pmos_3p3_noib='(fnoicor==0)*1.8e+020 + (fnoicor==1)*1.8e+020'
 +pmos_3p3_noic='(fnoicor==0)*3.0e+009 + (fnoicor==1)*6.0e+009'
.model  nmos_3p3.0  nmos
+level = 54
+lmin    = 2.8e-007
+lmax    = 5e-007
+wmin    = 2.2e-007
+wmax    = 5e-007
+version = 4.5
+binunit = 2
+paramchk= 1
+mobmod  = 0
+capmod  = 2
+igcmod  = 0
+igbmod  = 0
+geomod  = 0
+diomod  = 1
+rdsmod  = 0
+rbodymod= 0
+rgatemod= 0
+permod  = 1
+acnqsmod= 0
+trnqsmod= 0
+tnom    = 25
+toxe    = 8.4e-009
+toxp    = 8.4e-009
+toxm    = 8e-009
+epsrox  = 3.9
+wint    = 1e-008
+lint    = 0
+ll      = 0
+wl      = 0
+lln     = 1
+wln     = 1
+lw      = 0
+ww      = 0
+lwn     = 1
+wwn     = 1
+lwl     = 0
+wwl     = 0
+xl      = 1.5e-008
+xw      = -1e-008
+dlc     = 0
+dwc     = 0
+xpart   = 0
+toxref  = 8e-009
+dlcig   = 1.5e-007
+vth0    = 0.78102964
+lvth0   = -4.1963855e-008
+wvth0   = -1.335093e-008
+pvth0   = 4.4048385e-016
+k1      = 0.97009364
+lk1     = -1.0850207e-007
+k2      = 0.057112207
+lk2     = -4.4586066e-008
+wk2     = -1.8436862e-008
+pk2     = 5.4388743e-015
+k3      = 0
+k3b     = 0
+w0      = 5e-007
+dvt0    = 0
+dvt1    = 0.53
+dvt2    = 0
+dvt0w   = 0
+dvt1w   = 0
+dvt2w   = 0
+dsub    = 0.5
+minv    = -0.25
+voffl   = 0
+dvtp0   = 0
+dvtp1   = 0
+lpe0    = 1.1e-007
+lpeb    = 0
+vbm     = -3
+xj      = 1e-007
+ngate   = 6e+019
+ndep    = 3e+017
+nsd     = 1e+020
+phin    = 0.07
+cdsc    = 0
+cdscb   = 0
+cdscd   = 0
+cit     = 0
+voff    = -0.12611751
+lvoff   = 4.1027149e-009
+wvoff   = 5.0842288e-009
+pvoff   = -1.4998475e-015
+nfactor = 1
+eta0    = 0.75
+etab    = -0.32
+u0      = 0.02365998
+lu0     = 4.9752231e-009
+wu0     = 4.3500625e-009
+pu0     = -6.5742214e-016
+ua      = -1.2009004e-009
+lua     = 7.4602352e-016
+wua     = 2.6594489e-016
+pua     = -1.428335e-022
+ub      = 3.4181442e-018
+lub     = -8.4745491e-025
+wub     = -3.9003587e-025
+pub     = 9.3519126e-032
+uc      = 2.2972174e-010
+luc     = -6.5971448e-017
+wuc     = -3.0846577e-017
+puc     = 5.4982075e-024
+eu      = 1.67
+vsat    = 82709.416
+lvsat   = -0.002811599
+wvsat   = -0.00033342533
+pvsat   = 1.3214515e-009
+a0      = 0.11164211
+la0     = -3.216124e-009
+wa0     = -5.9711692e-009
+pa0     = 1.7614949e-015
+ags     = 0.33078713
+lags    = -1.7784597e-008
+wags    = 4.5802637e-008
+pags    = -1.2329143e-014
+a1      = 0
+a2      = 1
+b0      = 0
+b1      = 0
+keta    = -0.15224321
+lketa   = 4.1863427e-008
+wketa   = 7.8363649e-009
+pketa   = -2.4490902e-015
+dwg     = 0
+dwb     = 0
+pclm    = 0.38126164
+lpclm   = -5.0349819e-008
+wpclm   = 1.8707045e-008
+ppclm   = 8.6466979e-015
+pdiblc1 = 0.39
+pdiblc2 = 0.003171
+pdiblcb = 0.2
+drout   = 0.56
+pvag    = 0
+delta   = 0.0032954546
+ldelta  = 3.4528409e-009
+pscbe1  = 6.6469e+008
+pscbe2  = 1.638e-005
+fprout  = 0
+pdits   = 0
+pditsd  = 0
+pditsl  = 0
+rsh     = 7
+rdsw    = 530
+rdswmin = 50
+rdwmin  = 0
+rswmin  = 0
+prwg    = 0
+prwb    = 0
+wr      = 1
+alpha0  = 2.689932e-006
+lalpha0 = -3.3259243e-013
+walpha0 = 4.6736083e-014
+palpha0 = -1.3787144e-020
+alpha1  = 0
+beta0   = 19.906217
+lbeta0  = 1.3969208e-007
+wbeta0  = 1.2873117e-007
+pbeta0  = 8.809677e-016
+agidl   = 1.3268e-010
+bgidl   = 1.8961e+009
+cgidl   = 0.5
+egidl   = 0.8
+cgso    = 1.23e-010
+cgdo    = 1.23e-010
+cgbo    = 1e-013
+cgdl    = 1.1e-010
+cgsl    = 1.1e-010
+clc     = 1e-007
+cle     = 0.6
+cf      = 0
+ckappas = 0.6
+ckappad = 0.6
+vfbcv   = -1
+acde    = 0.6
+moin    = 15
+noff    = 2
+voffcv  = 0.005
+tvoff   = 0.001
+ltvoff  = 0
+wtvoff  = 0
+ptvoff  = 0
+kt1     = -0.46042018
+lkt1    = 4.4736487e-008
+wkt1    = 3.0709777e-008
+pkt1    = -8.7347947e-015
+kt1l    = 0
+kt2     = -0.024751234
+lkt2    = 1.327864e-009
+wkt2    = 1.0153526e-009
+pkt2    = -2.9952902e-016
+ute     = -1.5659091
+lute    = 9.3719968e-008
+wute    = 1.0147727e-007
+pute    = -4.4048385e-014
+ua1     = 1.675e-009
+ub1     = -4.1897925e-018
+lub1    = 3.0544077e-025
+wub1    = 3.1727957e-025
+pub1    = -5.8033747e-032
+uc1     = -4.2656818e-011
+luc1    = -3.9362386e-018
+wuc1    = -6.2712955e-018
+puc1    = 1.8500322e-024
+prt     = 0
+at      = 23000
+fnoimod = 1
+tnoimod = 0
+em      = 4.1e+007
+ef      = 0.95
+noia    = nmos_3p3_noia
+noib    = nmos_3p3_noib
+noic    = nmos_3p3_noic
+ntnoi   = 1
+jss     = 2.2959e-007
+jsws    = 2.1207e-013
+jswgs   = 0
+njs     = 1.01
+ijthsfwd= 0.1
+ijthsrev= 0.1
+pbs     = 0.70172
+cjs     = 0.00096797
+mjs     = 0.32071
+pbsws   = 0.8062
+cjsws   = 1.5663e-010
+mjsws   = 0.1
+pbswgs  = 0.74743
+cjswgs  = 5.9903e-010
+mjswgs  = 0.32059
+tpb     = 0.0018129
+tcj     = 0.0009438
+tpbsw   = 5e-005
+tcjsw   = 0.00060474
+tpbswg  = 0.0016872
+tcjswg  = 0.001
+xtis    = 3
+dmcg    = 1.5e-007
+saref   = 4.4e-007
+sbref   = 4.4e-007
+kvth0   = 0
+ku0     = 0
+kvsat   = 0

.model  nmos_3p3.1  nmos
+level = 54
+lmin    = 5e-007
+lmax    = 1.2e-006
+wmin    = 2.2e-007
+wmax    = 5e-007
+version = 4.5
+binunit = 2
+paramchk= 1
+mobmod  = 0
+capmod  = 2
+igcmod  = 0
+igbmod  = 0
+geomod  = 0
+diomod  = 1
+rdsmod  = 0
+rbodymod= 0
+rgatemod= 0
+permod  = 1
+acnqsmod= 0
+trnqsmod= 0
+tnom    = 25
+toxe    = 8.4e-009
+toxp    = 8.4e-009
+toxm    = 8e-009
+epsrox  = 3.9
+wint    = 1e-008
+lint    = 0
+ll      = 0
+wl      = 0
+lln     = 1
+wln     = 1
+lw      = 0
+ww      = 0
+lwn     = 1
+wwn     = 1
+lwl     = 0
+wwl     = 0
+xl      = 1.5e-008
+xw      = -1e-008
+dlc     = 0
+dwc     = 0
+xpart   = 0
+toxref  = 8e-009
+dlcig   = 1.5e-007
+vth0    = 0.7471174
+lvth0   = -2.4499049e-008
+wvth0   = -1.1432769e-008
+pvth0   = -5.4736891e-016
+k1      = 0.74623593
+lk1     = 6.7846468e-009
+k2      = 0.024093133
+lk2     = -2.7581243e-008
+wk2     = -2.7392647e-009
+pk2     = -2.6453883e-015
+k3      = 0
+k3b     = 0
+w0      = 5e-007
+dvt0    = 0
+dvt1    = 0.53
+dvt2    = 0
+dvt0w   = 0
+dvt1w   = 0
+dvt2w   = 0
+dsub    = 0.5
+minv    = -0.25
+voffl   = 0
+dvtp0   = 0
+dvtp1   = 0
+lpe0    = 1.1e-007
+lpeb    = 0
+vbm     = -3
+xj      = 1e-007
+ngate   = 6e+019
+ndep    = 3e+017
+nsd     = 1e+020
+phin    = 0.07
+cdsc    = 0
+cdscb   = 0
+cdscd   = 0
+cit     = 0
+voff    = -0.11249326
+lvoff   = -2.9137715e-009
+wvoff   = 1.5685135e-009
+pvoff   = 3.1074589e-016
+nfactor = 1
+eta0    = 0.75
+etab    = -0.32
+u0      = 0.02972055
+lu0     = 1.8540296e-009
+wu0     = 7.6900741e-010
+pu0     = 1.1868212e-015
+ua      = -1.310512e-009
+lua     = 8.0247348e-016
+wua     = 4.4658224e-017
+pua     = -2.8870859e-023
+ub      = 3.0972222e-018
+lub     = -6.8218008e-025
+wub     = -2.2900119e-026
+pub     = -9.5555786e-032
+uc      = 8.4637593e-011
+luc     = 8.7468885e-018
+wuc     = 2.3616893e-018
+puc     = -1.160405e-023
+eu      = 1.67
+vsat    = 73344.643
+lvsat   = 0.0020112589
+wvsat   = -0.0016424821
+pvsat   = 1.9956158e-009
+a0      = 1.0928896
+la0     = -5.0855857e-007
+wa0     = -4.894097e-008
+pa0     = 2.3890942e-014
+ags     = 0.48554907
+lags    = -9.7486997e-008
+wags    = 4.0512289e-008
+pags    = -9.6046138e-015
+a1      = 0
+a2      = 1
+b0      = 0
+b1      = 0
+keta    = -0.028668661
+lketa   = -2.1777465e-008
+wketa   = -7.0328534e-009
+pketa   = 5.2085573e-015
+dwg     = 0
+dwb     = 0
+pclm    = 0.085016691
+lpclm   = 1.0221633e-007
+wpclm   = 4.0905118e-008
+ppclm   = -2.7853095e-015
+pdiblc1 = 0.39
+pdiblc2 = 0.00133635
+lpdiblc2= 9.4484475e-010
+pdiblcb = 0.2
+drout   = 0.56
+pvag    = 0
+delta   = 0.0013214286
+ldelta  = 4.4694643e-009
+pscbe1  = 6.6469e+008
+pscbe2  = 1.638e-005
+fprout  = 0
+pdits   = 0
+pditsd  = 0
+pditsl  = 0
+rsh     = 7
+rdsw    = 530
+rdswmin = 50
+rdwmin  = 0
+rswmin  = 0
+prwg    = 0
+prwb    = 0
+wr      = 1
+alpha0  = 6.6270642e-006
+lalpha0 = -2.3602156e-012
+walpha0 = -1.4688483e-014
+palpha0 = 1.7846507e-020
+alpha1  = 0
+beta0   = 22.618932
+lbeta0  = -1.2573561e-006
+wbeta0  = -3.3178823e-007
+pbeta0  = 2.3804846e-013
+agidl   = 1.3268e-010
+bgidl   = 1.8961e+009
+cgidl   = 0.5
+egidl   = 0.8
+cgso    = 1.23e-010
+cgdo    = 1.23e-010
+cgbo    = 1e-013
+cgdl    = 1.1e-010
+cgsl    = 1.1e-010
+clc     = 1e-007
+cle     = 0.6
+cf      = 0
+ckappas = 0.6
+ckappad = 0.6
+vfbcv   = -1
+acde    = 0.6
+moin    = 15
+noff    = 2
+voffcv  = 0.005
+tvoff   = 0.001
+ltvoff  = 0
+wtvoff  = 0
+ptvoff  = 0
+kt1     = -0.33899638
+lkt1    = -1.7796768e-008
+wkt1    = -2.4927001e-009
+pkt1    = 8.3644811e-015
+kt1l    = 0
+kt2     = -0.020292087
+lkt2    = -9.6859676e-010
+wkt2    = -4.2326378e-011
+pkt2    = 2.4517566e-016
+ute     = -1.3839286
+wute    = 1.5946429e-008
+ua1     = 1.675e-009
+ub1     = -2.788493e-018
+lub1    = -4.1622844e-025
+wub1    = 5.1032672e-026
+pub1    = 7.9083403e-032
+uc1     = -6.0193571e-011
+luc1    = 5.0951893e-018
+wuc1    = 1.9709786e-018
+puc1    = -2.394739e-024
+prt     = 0
+at      = 23000
+fnoimod = 1
+tnoimod = 0
+em      = 4.1e+007
+ef      = 0.95
+noia    = nmos_3p3_noia
+noib    = nmos_3p3_noib
+noic    = nmos_3p3_noic
+ntnoi   = 1
+jss     = 2.2959e-007
+jsws    = 2.1207e-013
+jswgs   = 0
+njs     = 1.01
+ijthsfwd= 0.1
+ijthsrev= 0.1
+pbs     = 0.70172
+cjs     = 0.00096797
+mjs     = 0.32071
+pbsws   = 0.8062
+cjsws   = 1.5663e-010
+mjsws   = 0.1
+pbswgs  = 0.74743
+cjswgs  = 5.9903e-010
+mjswgs  = 0.32059
+tpb     = 0.0018129
+tcj     = 0.0009438
+tpbsw   = 5e-005
+tcjsw   = 0.00060474
+tpbswg  = 0.0016872
+tcjswg  = 0.001
+xtis    = 3
+dmcg    = 1.5e-007
+saref   = 4.4e-007
+sbref   = 4.4e-007
+kvth0   = 0
+ku0     = 0
+kvsat   = 0

.model  nmos_3p3.2  nmos
+level = 54
+lmin    = 1.2e-006
+lmax    = 1e-005
+wmin    = 2.2e-007
+wmax    = 5e-007
+version = 4.5
+binunit = 2
+paramchk= 1
+mobmod  = 0
+capmod  = 2
+igcmod  = 0
+igbmod  = 0
+geomod  = 0
+diomod  = 1
+rdsmod  = 0
+rbodymod= 0
+rgatemod= 0
+permod  = 1
+acnqsmod= 0
+trnqsmod= 0
+tnom    = 25
+toxe    = 8.4e-009
+toxp    = 8.4e-009
+toxm    = 8e-009
+epsrox  = 3.9
+wint    = 1e-008
+lint    = 0
+ll      = 0
+wl      = 0
+lln     = 1
+wln     = 1
+lw      = 0
+ww      = 0
+lwn     = 1
+wwn     = 1
+lwl     = 0
+wwl     = 0
+xl      = 1.5e-008
+xw      = -1e-008
+dlc     = 0
+dwc     = 0
+xpart   = 0
+toxref  = 8e-009
+dlcig   = 1.5e-007
+vth0    = 0.72996498
+lvth0   = -3.6588628e-009
+wvth0   = -9.0195048e-009
+pvth0   = -3.4794852e-015
+k1      = 0.79599981
+lk1     = -5.3678465e-008
+k2      = 0.0048675395
+lk2     = -4.2221469e-009
+wk2     = -6.9420874e-009
+pk2     = 2.4610412e-015
+k3      = 0
+k3b     = 0
+w0      = 5e-007
+dvt0    = 0
+dvt1    = 0.53
+dvt2    = 0
+dvt0w   = 0
+dvt1w   = 0
+dvt2w   = 0
+dsub    = 0.5
+minv    = -0.25
+voffl   = 0
+dvtp0   = 0
+dvtp1   = 0
+lpe0    = 1.1e-007
+lpeb    = 0
+vbm     = -3
+xj      = 1e-007
+ngate   = 6e+019
+ndep    = 3e+017
+nsd     = 1e+020
+phin    = 0.07
+cdsc    = 0
+cdscb   = 0
+cdscd   = 0
+cit     = 0
+voff    = -0.12611319
+lvoff   = 1.3634437e-008
+wvoff   = 1.9367898e-009
+pvoff   = -1.3670981e-016
+nfactor = 1
+eta0    = 0.75
+etab    = -0.32
+u0      = 0.032519064
+lu0     = -1.5461646e-009
+wu0     = 6.2244619e-010
+pu0     = 1.3648931e-015
+ua      = -8.1508834e-010
+lua     = 2.0053373e-016
+wua     = 5.600962e-018
+pua     = 1.8583714e-023
+ub      = 2.7414305e-018
+lub     = -2.4989307e-025
+wub     = -1.4798829e-026
+pub     = -1.0539885e-031
+uc      = 9.7550228e-011
+luc     = -6.9419625e-018
+wuc     = -8.2782193e-018
+puc     = 1.3234392e-024
+eu      = 1.67
+vsat    = 75000
+a0      = 1.2256909
+la0     = -6.6991215e-007
+wa0     = 4.0423109e-009
+pa0     = -4.0483744e-014
+ags     = 0.25735343
+lags    = 1.7977071e-007
+wags    = -2.4766942e-009
+pags    = 4.2627001e-014
+a1      = 0
+a2      = 1
+b0      = 0
+b1      = 0
+keta    = -0.019679504
+lketa   = -3.269929e-008
+wketa   = -6.1066685e-010
+pketa   = -2.5943994e-015
+dwg     = 0
+dwb     = 0
+pclm    = 0.18943996
+lpclm   = -2.465794e-008
+wpclm   = 1.9498441e-009
+ppclm   = 4.4545348e-014
+pdiblc1 = 0.39
+pdiblc2 = 0.00063792557
+lpdiblc2= 1.7934304e-009
+pdiblcb = 0.2
+drout   = 0.56
+pvag    = 0
+delta   = 0.0027238636
+ldelta  = 2.7655057e-009
+pscbe1  = 6.6469e+008
+pscbe2  = 1.638e-005
+fprout  = 0
+pdits   = 0
+pditsd  = 0
+pditsl  = 0
+rsh     = 7
+rdsw    = 530
+rdswmin = 50
+rdwmin  = 0
+rswmin  = 0
+prwg    = 0
+prwb    = 0
+wr      = 1
+alpha0  = 7.6135347e-005
+lalpha0 = -8.6812779e-011
+walpha0 = 7.0204199e-012
+palpha0 = -8.5298102e-018
+alpha1  = 0
+beta0   = 24.225975
+lbeta0  = -3.2099126e-006
+wbeta0  = 1.0623239e-007
+pbeta0  = -2.9414659e-013
+agidl   = 1.3268e-010
+bgidl   = 1.8961e+009
+cgidl   = 0.5
+egidl   = 0.8
+cgso    = 1.23e-010
+cgdo    = 1.23e-010
+cgbo    = 1e-013
+cgdl    = 1.1e-010
+cgsl    = 1.1e-010
+clc     = 1e-007
+cle     = 0.6
+cf      = 0
+ckappas = 0.6
+ckappad = 0.6
+vfbcv   = -1
+acde    = 0.6
+moin    = 15
+noff    = 2
+voffcv  = 0.005
+tvoff   = 0.001
+ltvoff  = 0
+wtvoff  = 0
+ptvoff  = 0
+kt1     = -0.32971157
+lkt1    = -2.9077811e-008
+wkt1    = -6.8565602e-009
+pkt1    = 1.3666571e-014
+kt1l    = 0
+kt2     = -0.021089286
+wkt2    = 1.5946429e-010
+ute     = -1.3839286
+wute    = 1.5946429e-008
+ua1     = 1.675e-009
+ub1     = -2.513361e-018
+lub1    = -7.505138e-025
+wub1    = 2.0553877e-026
+pub1    = 1.1611514e-031
+uc1     = -5.6e-011
+prt     = 0
+at      = 23000
+fnoimod = 1
+tnoimod = 0
+em      = 4.1e+007
+ef      = 0.95
+noia    = nmos_3p3_noia
+noib    = nmos_3p3_noib
+noic    = nmos_3p3_noic
+ntnoi   = 1
+jss     = 2.2959e-007
+jsws    = 2.1207e-013
+jswgs   = 0
+njs     = 1.01
+ijthsfwd= 0.1
+ijthsrev= 0.1
+pbs     = 0.70172
+cjs     = 0.00096797
+mjs     = 0.32071
+pbsws   = 0.8062
+cjsws   = 1.5663e-010
+mjsws   = 0.1
+pbswgs  = 0.74743
+cjswgs  = 5.9903e-010
+mjswgs  = 0.32059
+tpb     = 0.0018129
+tcj     = 0.0009438
+tpbsw   = 5e-005
+tcjsw   = 0.00060474
+tpbswg  = 0.0016872
+tcjswg  = 0.001
+xtis    = 3
+dmcg    = 1.5e-007
+saref   = 4.4e-007
+sbref   = 4.4e-007
+kvth0   = 0
+ku0     = 0
+kvsat   = 0

.model  nmos_3p3.3  nmos
+level = 54
+lmin    = 1e-005
+lmax    = 5.0001e-005
+wmin    = 2.2e-007
+wmax    = 5e-007
+version = 4.5
+binunit = 2
+paramchk= 1
+mobmod  = 0
+capmod  = 2
+igcmod  = 0
+igbmod  = 0
+geomod  = 0
+diomod  = 1
+rdsmod  = 0
+rbodymod= 0
+rgatemod= 0
+permod  = 1
+acnqsmod= 0
+trnqsmod= 0
+tnom    = 25
+toxe    = 8.4e-009
+toxp    = 8.4e-009
+toxm    = 8e-009
+epsrox  = 3.9
+wint    = 1e-008
+lint    = 0
+ll      = 0
+wl      = 0
+lln     = 1
+wln     = 1
+lw      = 0
+ww      = 0
+lwn     = 1
+wwn     = 1
+lwl     = 0
+wwl     = 0
+xl      = 1.5e-008
+xw      = -1e-008
+dlc     = 0
+dwc     = 0
+xpart   = 0
+toxref  = 8e-009
+dlcig   = 1.5e-007
+vth0    = 0.72959964
+wvth0   = -9.3669321e-009
+k1      = 0.79064
+k2      = 0.0044459571
+wk2     = -6.6963519e-009
+k3      = 0
+k3b     = 0
+w0      = 5e-007
+dvt0    = 0
+dvt1    = 0.53
+dvt2    = 0
+dvt0w   = 0
+dvt1w   = 0
+dvt2w   = 0
+dsub    = 0.5
+minv    = -0.25
+voffl   = 0
+dvtp0   = 0
+dvtp1   = 0
+lpe0    = 1.1e-007
+lpeb    = 0
+vbm     = -3
+xj      = 1e-007
+ngate   = 6e+019
+ndep    = 3e+017
+nsd     = 1e+020
+phin    = 0.07
+cdsc    = 0
+cdscb   = 0
+cdscd   = 0
+cit     = 0
+voff    = -0.12475179
+wvoff   = 1.9231393e-009
+nfactor = 1
+eta0    = 0.75
+etab    = -0.32
+u0      = 0.032364679
+wu0     = 7.5873107e-010
+ua      = -7.95065e-010
+wua     = 7.45655e-018
+ub      = 2.7164786e-018
+wub     = -2.5322929e-026
+uc      = 9.6857071e-011
+wuc     = -8.1460736e-018
+eu      = 1.67
+vsat    = 75000
+a0      = 1.1588
+ags     = 0.27530357
+wags    = 1.7796214e-009
+a1      = 0
+a2      = 1
+b0      = 0
+b1      = 0
+keta    = -0.022944536
+wketa   = -8.6971821e-010
+dwg     = 0
+dwb     = 0
+pclm    = 0.18697786
+wpclm   = 6.3977071e-009
+pdiblc1 = 0.39
+pdiblc2 = 0.000817
+pdiblcb = 0.2
+drout   = 0.56
+pvag    = 0
+delta   = 0.003
+pscbe1  = 6.6469e+008
+pscbe2  = 1.638e-005
+fprout  = 0
+pdits   = 0
+pditsd  = 0
+pditsl  = 0
+rsh     = 7
+rdsw    = 530
+rdswmin = 50
+rdwmin  = 0
+rswmin  = 0
+prwg    = 0
+prwb    = 0
+wr      = 1
+alpha0  = 6.7467071e-005
+walpha0 = 6.1687164e-012
+alpha1  = 0
+beta0   = 23.905464
+wbeta0  = 7.6861786e-008
+agidl   = 1.3268e-010
+bgidl   = 1.8961e+009
+cgidl   = 0.5
+egidl   = 0.8
+cgso    = 1.23e-010
+cgdo    = 1.23e-010
+cgbo    = 1e-013
+cgdl    = 1.1e-010
+cgsl    = 1.1e-010
+clc     = 1e-007
+cle     = 0.6
+cf      = 0
+ckappas = 0.6
+ckappad = 0.6
+vfbcv   = -1
+acde    = 0.6
+moin    = 15
+noff    = 2
+voffcv  = 0.005
+tvoff   = 0.001
+ltvoff  = 0
+wtvoff  = 0
+ptvoff  = 0
+kt1     = -0.332615
+wkt1    = -5.49195e-009
+kt1l    = 0
+kt2     = -0.021089286
+wkt2    = 1.5946429e-010
+ute     = -1.3839286
+wute    = 1.5946429e-008
+ua1     = 1.675e-009
+ub1     = -2.5883e-018
+wub1    = 3.2148e-026
+uc1     = -5.6e-011
+prt     = 0
+at      = 23000
+fnoimod = 1
+tnoimod = 0
+em      = 4.1e+007
+ef      = 0.95
+noia    = nmos_3p3_noia
+noib    = nmos_3p3_noib
+noic    = nmos_3p3_noic
+ntnoi   = 1
+jss     = 2.2959e-007
+jsws    = 2.1207e-013
+jswgs   = 0
+njs     = 1.01
+ijthsfwd= 0.1
+ijthsrev= 0.1
+pbs     = 0.70172
+cjs     = 0.00096797
+mjs     = 0.32071
+pbsws   = 0.8062
+cjsws   = 1.5663e-010
+mjsws   = 0.1
+pbswgs  = 0.74743
+cjswgs  = 5.9903e-010
+mjswgs  = 0.32059
+tpb     = 0.0018129
+tcj     = 0.0009438
+tpbsw   = 5e-005
+tcjsw   = 0.00060474
+tpbswg  = 0.0016872
+tcjswg  = 0.001
+xtis    = 3
+dmcg    = 1.5e-007
+saref   = 4.4e-007
+sbref   = 4.4e-007
+kvth0   = 0
+ku0     = 0
+kvsat   = 0

.model  nmos_3p3.4  nmos
+level = 54
+lmin    = 2.8e-007
+lmax    = 5e-007
+wmin    = 5e-007
+wmax    = 1.2e-006
+version = 4.5
+binunit = 2
+paramchk= 1
+mobmod  = 0
+capmod  = 2
+igcmod  = 0
+igbmod  = 0
+geomod  = 0
+diomod  = 1
+rdsmod  = 0
+rbodymod= 0
+rgatemod= 0
+permod  = 1
+acnqsmod= 0
+trnqsmod= 0
+tnom    = 25
+toxe    = 8.4e-009
+toxp    = 8.4e-009
+toxm    = 8e-009
+epsrox  = 3.9
+wint    = 1e-008
+lint    = 0
+ll      = 0
+wl      = 0
+lln     = 1
+wln     = 1
+lw      = 0
+ww      = 0
+lwn     = 1
+wwn     = 1
+lwl     = 0
+wwl     = 0
+xl      = 1.5e-008
+xw      = -1e-008
+dlc     = 0
+dwc     = 0
+xpart   = 0
+toxref  = 8e-009
+dlcig   = 1.5e-007
+vth0    = 0.79767867
+lvth0   = -4.5516631e-008
+wvth0   = -2.1175971e-008
+pvth0   = 2.1102886e-015
+k1      = 0.97009364
+lk1     = -1.0850207e-007
+k2      = 0.045081757
+lk2     = -4.1037083e-008
+wk2     = -1.2782551e-008
+pk2     = 3.7708524e-015
+k3      = 0
+k3b     = 0
+w0      = 5e-007
+dvt0    = 0
+dvt1    = 0.53
+dvt2    = 0
+dvt0w   = 0
+dvt1w   = 0
+dvt2w   = 0
+dsub    = 0.5
+minv    = -0.25
+voffl   = 0
+dvtp0   = 0
+dvtp1   = 0
+lpe0    = 1.1e-007
+lpeb    = 0
+vbm     = -3
+xj      = 1e-007
+ngate   = 6e+019
+ndep    = 3e+017
+nsd     = 1e+020
+phin    = 0.07
+cdsc    = 0
+cdscb   = 0
+cdscd   = 0
+cit     = 0
+voff    = -0.078638354
+lvoff   = -9.9036356e-009
+wvoff   = -1.7230974e-008
+pvoff   = 5.0831372e-015
+nfactor = 1
+eta0    = 0.75
+etab    = -0.32
+u0      = 0.032583121
+lu0     = 4.3613327e-009
+wu0     = 1.5618588e-010
+pu0     = -3.6889363e-016
+ua      = -6.7252796e-010
+lua     = 4.3347724e-016
+wua     = 1.7609833e-017
+pua     = 4.0632548e-024
+ub      = 2.2958092e-018
+lub     = -1.0258242e-025
+wub     = 1.3746161e-025
+pub     = -2.5657094e-031
+uc      = 1.6246617e-010
+luc     = -3.7418989e-017
+wuc     = 7.6353972e-019
+puc     = -7.9214482e-024
+eu      = 1.67
+vsat    = 61335.065
+lvsat   = 0.0046169416
+wvsat   = 0.0097125195
+pvsat   = -2.1699625e-009
+a0      = 0.10691933
+la0     = -1.8229027e-009
+wa0     = -3.7514606e-009
+pa0     = 1.1066809e-015
+ags     = 0.35687524
+lags    = -1.304868e-008
+wags    = 3.3541222e-008
+pags    = -1.4555024e-014
+a1      = 0
+a2      = 1
+b0      = 0
+b1      = 0
+keta    = -0.12821436
+lketa   = 3.2864396e-008
+wketa   = -3.4571927e-009
+pketa   = 1.7804543e-015
+dwg     = 0
+dwb     = 0
+pclm    = 0.46740308
+lpclm   = -8.6444043e-008
+wpclm   = -2.1779432e-008
+ppclm   = 2.5610983e-014
+pdiblc1 = 0.39
+pdiblc2 = 0.003171
+pdiblcb = 0.2
+drout   = 0.56
+pvag    = 0
+delta   = 0.0032954546
+ldelta  = 3.4528409e-009
+pscbe1  = 6.6469e+008
+pscbe2  = 1.638e-005
+fprout  = 0
+pdits   = 0
+pditsd  = 0
+pditsl  = 0
+rsh     = 7
+rdsw    = 530
+rdswmin = 50
+rdwmin  = 0
+rswmin  = 0
+prwg    = 0
+prwb    = 0
+wr      = 1
+alpha0  = 2.6811189e-006
+lalpha0 = -3.0617722e-013
+walpha0 = 5.0878248e-014
+palpha0 = -2.6202298e-020
+alpha1  = 0
+beta0   = 20.985552
+lbeta0  = -9.5051778e-008
+wbeta0  = -3.7855616e-007
+pbeta0  = 1.1121058e-013
+agidl   = 1.3268e-010
+bgidl   = 1.8961e+009
+cgidl   = 0.5
+egidl   = 0.8
+cgso    = 1.23e-010
+cgdo    = 1.23e-010
+cgbo    = 1e-013
+cgdl    = 1.1e-010
+cgsl    = 1.1e-010
+clc     = 1e-007
+cle     = 0.6
+cf      = 0
+ckappas = 0.6
+ckappad = 0.6
+vfbcv   = -1
+acde    = 0.6
+moin    = 15
+noff    = 2
+voffcv  = 0.005
+tvoff   = 0.001
+ltvoff  = 0
+wtvoff  = 0
+ptvoff  = 0
+kt1     = -0.37966054
+lkt1    = 1.8210678e-008
+wkt1    = -7.2472535e-009
+pkt1    = 3.7323356e-015
+kt1l    = 0
+kt2     = -0.014318515
+lkt2    = -3.5697146e-009
+wkt2    = -3.8880251e-009
+pkt2    = 2.0023329e-015
+ute     = -1.4335714
+wute    = 3.9278571e-008
+ua1     = 1.675e-009
+ub1     = -3.6841668e-018
+lub1    = 2.6922491e-025
+wub1    = 7.9635518e-026
+pub1    = -4.1012292e-032
+uc1     = -5.6e-011
+prt     = 0
+at      = 23000
+fnoimod = 1
+tnoimod = 0
+em      = 4.1e+007
+ef      = 0.95
+noia    = nmos_3p3_noia
+noib    = nmos_3p3_noib
+noic    = nmos_3p3_noic
+ntnoi   = 1
+jss     = 2.2959e-007
+jsws    = 2.1207e-013
+jswgs   = 0
+njs     = 1.01
+ijthsfwd= 0.1
+ijthsrev= 0.1
+pbs     = 0.70172
+cjs     = 0.00096797
+mjs     = 0.32071
+pbsws   = 0.8062
+cjsws   = 1.5663e-010
+mjsws   = 0.1
+pbswgs  = 0.74743
+cjswgs  = 5.9903e-010
+mjswgs  = 0.32059
+tpb     = 0.0018129
+tcj     = 0.0009438
+tpbsw   = 5e-005
+tcjsw   = 0.00060474
+tpbswg  = 0.0016872
+tcjswg  = 0.001
+xtis    = 3
+dmcg    = 1.5e-007
+saref   = 4.4e-007
+sbref   = 4.4e-007
+kvth0   = 0
+ku0     = 0
+kvsat   = 0

.model  nmos_3p3.5  nmos
+level = 54
+lmin    = 5e-007
+lmax    = 1.2e-006
+wmin    = 5e-007
+wmax    = 1.2e-006
+version = 4.5
+binunit = 2
+paramchk= 1
+mobmod  = 0
+capmod  = 2
+igcmod  = 0
+igbmod  = 0
+geomod  = 0
+diomod  = 1
+rdsmod  = 0
+rbodymod= 0
+rgatemod= 0
+permod  = 1
+acnqsmod= 0
+trnqsmod= 0
+tnom    = 25
+toxe    = 8.4e-009
+toxp    = 8.4e-009
+toxm    = 8e-009
+epsrox  = 3.9
+wint    = 1e-008
+lint    = 0
+ll      = 0
+wl      = 0
+lln     = 1
+wln     = 1
+lw      = 0
+ww      = 0
+lwn     = 1
+wwn     = 1
+lwl     = 0
+wwl     = 0
+xl      = 1.5e-008
+xw      = -1e-008
+dlc     = 0
+dwc     = 0
+xpart   = 0
+toxref  = 8e-009
+dlcig   = 1.5e-007
+vth0    = 0.74529086
+lvth0   = -1.8536912e-008
+wvth0   = -1.0574296e-008
+pvth0   = -3.3495736e-015
+k1      = 0.76825545
+lk1     = -4.5554057e-009
+wk1     = -1.0349174e-008
+pk1     = 5.3298247e-015
+k2      = 0.0088249226
+lk2     = -2.2364814e-008
+wk2     = 4.4367941e-009
+pk2     = -5.0971101e-015
+k3      = 0
+k3b     = 0
+w0      = 5e-007
+dvt0    = 0
+dvt1    = 0.53
+dvt2    = 0
+dvt0w   = 0
+dvt1w   = 0
+dvt2w   = 0
+dsub    = 0.5
+minv    = -0.25
+voffl   = 0
+dvtp0   = 0
+dvtp1   = 0
+lpe0    = 1.1e-007
+lpeb    = 0
+vbm     = -3
+xj      = 1e-007
+ngate   = 6e+019
+ndep    = 3e+017
+nsd     = 1e+020
+phin    = 0.07
+cdsc    = 0
+cdscb   = 0
+cdscd   = 0
+cit     = 0
+voff    = -0.12067823
+lvoff   = 1.1746901e-008
+wvoff   = 5.4154489e-009
+pvoff   = -6.5797704e-015
+nfactor = 1
+eta0    = 0.75
+etab    = -0.32
+u0      = 0.031060188
+lu0     = 5.1456432e-009
+wu0     = 1.393772e-010
+pu0     = -3.6023716e-016
+ua      = -1.1755786e-009
+lua     = 6.9254834e-016
+wua     = -1.8760456e-017
+pua     = 2.2793954e-023
+ub      = 2.834859e-018
+lub     = -3.8019306e-025
+wub     = 1.0041062e-025
+pub     = -2.3748968e-031
+uc      = 8.1961894e-011
+luc     = 4.040715e-018
+wuc     = 3.6192678e-018
+puc     = -9.3921482e-024
+eu      = 1.67
+vsat    = 78457.857
+lvsat   = -0.0042012964
+wvsat   = -0.0040456929
+pvsat   = 4.9155168e-009
+a0      = 0.98625128
+la0     = -4.5467886e-007
+wa0     = 1.1790305e-009
+pa0     = -1.432522e-015
+ags     = 0.44354017
+lags    = -5.7681118e-008
+wags    = 6.0256471e-008
+pags    = -2.8313377e-014
+a1      = 0
+a2      = 1
+b0      = 0
+b1      = 0
+keta    = -0.043632179
+lketa   = -1.0695428e-008
+dwg     = 0
+dwb     = 0
+pclm    = 0.21580136
+lpclm   = 4.3130841e-008
+wpclm   = -2.0563679e-008
+ppclm   = 2.498487e-014
+pdiblc1 = 0.39
+pdiblc2 = 0.00133635
+lpdiblc2= 9.4484475e-010
+pdiblcb = 0.2
+drout   = 0.56
+pvag    = 0
+delta   = 0.0013214286
+ldelta  = 4.4694643e-009
+pscbe1  = 6.6469e+008
+pscbe2  = 1.638e-005
+fprout  = 0
+pdits   = 0
+pditsd  = 0
+pditsl  = 0
+rsh     = 7
+rdsw    = 530
+rdswmin = 50
+rdwmin  = 0
+rswmin  = 0
+prwg    = 0
+prwb    = 0
+wr      = 1
+alpha0  = 6.8731595e-006
+lalpha0 = -2.4650781e-012
+walpha0 = -1.3035323e-013
+palpha0 = 6.7131915e-020
+alpha1  = 0
+beta0   = 21.046316
+lbeta0  = -1.2634537e-007
+wbeta0  = 4.0734123e-007
+pbeta0  = -2.9352658e-013
+agidl   = 1.3268e-010
+bgidl   = 1.8961e+009
+cgidl   = 0.5
+egidl   = 0.8
+cgso    = 1.23e-010
+cgdo    = 1.23e-010
+cgbo    = 1e-013
+cgdl    = 1.1e-010
+cgsl    = 1.1e-010
+clc     = 1e-007
+cle     = 0.6
+cf      = 0
+ckappas = 0.6
+ckappad = 0.6
+vfbcv   = -1
+acde    = 0.6
+moin    = 15
+noff    = 2
+voffcv  = 0.005
+tvoff   = 0.001
+ltvoff  = 0
+wtvoff  = 0
+ptvoff  = 0
+kt1     = -0.40824074
+lkt1    = 3.292948e-008
+wkt1    = 3.0052147e-008
+pkt1    = -1.5476856e-014
+kt1l    = 0
+kt2     = -0.031261352
+lkt2    = 5.1558463e-009
+wkt2    = 5.1132283e-009
+pkt2    = -2.6333126e-015
+ute     = -1.4335714
+wute    = 3.9278571e-008
+ua1     = 1.675e-009
+ub1     = -2.804371e-018
+lub1    = -1.8386993e-025
+wub1    = 5.8495332e-026
+pub1    = -3.0125096e-032
+uc1     = -1.1913423e-010
+luc1    = 3.2514127e-017
+wuc1    = 2.9673087e-017
+puc1    = -1.528164e-023
+prt     = 0
+at      = 23000
+fnoimod = 1
+tnoimod = 0
+em      = 4.1e+007
+ef      = 0.95
+noia    = nmos_3p3_noia
+noib    = nmos_3p3_noib
+noic    = nmos_3p3_noic
+ntnoi   = 1
+jss     = 2.2959e-007
+jsws    = 2.1207e-013
+jswgs   = 0
+njs     = 1.01
+ijthsfwd= 0.1
+ijthsrev= 0.1
+pbs     = 0.70172
+cjs     = 0.00096797
+mjs     = 0.32071
+pbsws   = 0.8062
+cjsws   = 1.5663e-010
+mjsws   = 0.1
+pbswgs  = 0.74743
+cjswgs  = 5.9903e-010
+mjswgs  = 0.32059
+tpb     = 0.0018129
+tcj     = 0.0009438
+tpbsw   = 5e-005
+tcjsw   = 0.00060474
+tpbswg  = 0.0016872
+tcjswg  = 0.001
+xtis    = 3
+dmcg    = 1.5e-007
+saref   = 4.4e-007
+sbref   = 4.4e-007
+kvth0   = 0
+ku0     = 0
+kvsat   = 0

.model  nmos_3p3.6  nmos
+level = 54
+lmin    = 1.2e-006
+lmax    = 1e-005
+wmin    = 5e-007
+wmax    = 1.2e-006
+version = 4.5
+binunit = 2
+paramchk= 1
+mobmod  = 0
+capmod  = 2
+igcmod  = 0
+igbmod  = 0
+geomod  = 0
+diomod  = 1
+rdsmod  = 0
+rbodymod= 0
+rgatemod= 0
+permod  = 1
+acnqsmod= 0
+trnqsmod= 0
+tnom    = 25
+toxe    = 8.4e-009
+toxp    = 8.4e-009
+toxm    = 8e-009
+epsrox  = 3.9
+wint    = 1e-008
+lint    = 0
+ll      = 0
+wl      = 0
+lln     = 1
+wln     = 1
+lw      = 0
+ww      = 0
+lwn     = 1
+wwn     = 1
+lwl     = 0
+wwl     = 0
+xl      = 1.5e-008
+xw      = -1e-008
+dlc     = 0
+dwc     = 0
+xpart   = 0
+toxref  = 8e-009
+dlcig   = 1.5e-007
+vth0    = 0.71914657
+lvth0   = 1.3228401e-008
+wvth0   = -3.9348514e-009
+pvth0   = -1.1416499e-014
+k1      = 0.79424825
+lk1     = -3.6136665e-008
+wk1     = 8.2322976e-010
+pk1     = -8.244646e-015
+k2      = -0.0057533677
+lk2     = -4.6521909e-009
+wk2     = -1.950261e-009
+pk2     = 2.6631619e-015
+k3      = 0
+k3b     = 0
+w0      = 5e-007
+dvt0    = 0
+dvt1    = 0.53
+dvt2    = 0
+dvt0w   = 0
+dvt1w   = 0
+dvt2w   = 0
+dsub    = 0.5
+minv    = -0.25
+voffl   = 0
+dvtp0   = 0
+dvtp1   = 0
+lpe0    = 1.1e-007
+lpeb    = 0
+vbm     = -3
+xj      = 1e-007
+ngate   = 6e+019
+ndep    = 3e+017
+nsd     = 1e+020
+phin    = 0.07
+cdsc    = 0
+cdscb   = 0
+cdscd   = 0
+cit     = 0
+voff    = -0.12199236
+lvoff   = 1.3343565e-008
+nfactor = 1
+eta0    = 0.75
+etab    = -0.32
+u0      = 0.036469853
+lu0     = -1.4270997e-009
+wu0     = -1.2344251e-009
+pu0     = 1.3089326e-015
+ua      = -7.8850544e-010
+lua     = 2.2225441e-016
+wua     = -6.893001e-018
+pua     = 8.3749962e-024
+ub      = 3.0573243e-018
+lub     = -6.5048842e-025
+wub     = -1.6326892e-025
+pub     = 8.2880961e-032
+uc      = 9.7426091e-011
+luc     = -1.4748284e-017
+wuc     = -8.2198748e-018
+puc     = 4.9924102e-024
+eu      = 1.67
+vsat    = 75000
+a0      = 1.2342915
+la0     = -7.5604777e-007
+ags     = 0.28327385
+lags    = 1.3704246e-007
+wags    = -1.4659294e-008
+pags    = 6.2709277e-014
+a1      = 0
+a2      = 1
+b0      = 0
+b1      = 0
+keta    = -0.020978796
+lketa   = -3.8219289e-008
+dwg     = 0
+dwb     = 0
+pclm    = 0.22676292
+lpclm   = 2.9812546e-008
+wpclm   = -1.559195e-008
+ppclm   = 1.894422e-014
+pdiblc1 = 0.39
+pdiblc2 = 0.00063792557
+lpdiblc2= 1.7934304e-009
+pdiblcb = 0.2
+drout   = 0.56
+pvag    = 0
+delta   = 0.0027238636
+ldelta  = 2.7655057e-009
+pscbe1  = 6.6469e+008
+pscbe2  = 1.638e-005
+fprout  = 0
+pdits   = 0
+pditsd  = 0
+pditsl  = 0
+rsh     = 7
+rdsw    = 530
+rdswmin = 50
+rdwmin  = 0
+rswmin  = 0
+prwg    = 0
+prwb    = 0
+wr      = 1
+alpha0  = 9.1050349e-005
+lalpha0 = -1.0474036e-010
+walpha0 = 1.0369007e-014
+palpha0 = -1.0384561e-019
+alpha1  = 0
+beta0   = 24.04797
+lbeta0  = -3.7733547e-006
+wbeta0  = 1.8989449e-007
+pbeta0  = -2.932878e-014
+agidl   = 1.3268e-010
+bgidl   = 1.8961e+009
+cgidl   = 0.5
+egidl   = 0.8
+cgso    = 1.23e-010
+cgdo    = 1.23e-010
+cgbo    = 1e-013
+cgdl    = 1.1e-010
+cgsl    = 1.1e-010
+clc     = 1e-007
+cle     = 0.6
+cf      = 0
+ckappas = 0.6
+ckappad = 0.6
+vfbcv   = -1
+acde    = 0.6
+moin    = 15
+noff    = 2
+voffcv  = 0.005
+tvoff   = 0.001
+ltvoff  = 0
+wtvoff  = 0
+ptvoff  = 0
+kt1     = -0.3392138
+lkt1    = -5.0938244e-008
+wkt1    = -2.3905117e-009
+pkt1    = 2.3940975e-014
+kt1l    = 0
+kt2     = -0.021786808
+lkt2    = -6.3557247e-009
+wkt2    = 4.8729978e-010
+pkt2    = 2.9871906e-015
+ute     = -1.7189014
+lute    = 3.4667589e-007
+wute    = 1.7338365e-007
+pute    = -1.6293767e-013
+ua1     = 1.675e-009
+ub1     = -3.5382765e-018
+lub1    = 7.0782525e-025
+wub1    = 5.0226415e-025
+pub1    = -5.6930421e-031
+uc1     = -5.0977959e-011
+luc1    = -5.0295738e-017
+wuc1    = -2.3603592e-018
+puc1    = 2.3638997e-023
+prt     = 0
+at      = 23000
+fnoimod = 1
+tnoimod = 0
+em      = 4.1e+007
+ef      = 0.95
+noia    = nmos_3p3_noia
+noib    = nmos_3p3_noib
+noic    = nmos_3p3_noic
+ntnoi   = 1
+jss     = 2.2959e-007
+jsws    = 2.1207e-013
+jswgs   = 0
+njs     = 1.01
+ijthsfwd= 0.1
+ijthsrev= 0.1
+pbs     = 0.70172
+cjs     = 0.00096797
+mjs     = 0.32071
+pbsws   = 0.8062
+cjsws   = 1.5663e-010
+mjsws   = 0.1
+pbswgs  = 0.74743
+cjswgs  = 5.9903e-010
+mjswgs  = 0.32059
+tpb     = 0.0018129
+tcj     = 0.0009438
+tpbsw   = 5e-005
+tcjsw   = 0.00060474
+tpbswg  = 0.0016872
+tcjswg  = 0.001
+xtis    = 3
+dmcg    = 1.5e-007
+saref   = 4.4e-007
+sbref   = 4.4e-007
+kvth0   = 0
+ku0     = 0
+kvsat   = 0

.model  nmos_3p3.7  nmos
+level = 54
+lmin    = 1e-005
+lmax    = 5.0001e-005
+wmin    = 5e-007
+wmax    = 1.2e-006
+version = 4.5
+binunit = 2
+paramchk= 1
+mobmod  = 0
+capmod  = 2
+igcmod  = 0
+igbmod  = 0
+geomod  = 0
+diomod  = 1
+rdsmod  = 0
+rbodymod= 0
+rgatemod= 0
+permod  = 1
+acnqsmod= 0
+trnqsmod= 0
+tnom    = 25
+toxe    = 8.4e-009
+toxp    = 8.4e-009
+toxm    = 8e-009
+epsrox  = 3.9
+wint    = 1e-008
+lint    = 0
+ll      = 0
+wl      = 0
+lln     = 1
+wln     = 1
+lw      = 0
+ww      = 0
+lwn     = 1
+wwn     = 1
+lwl     = 0
+wwl     = 0
+xl      = 1.5e-008
+xw      = -1e-008
+dlc     = 0
+dwc     = 0
+xpart   = 0
+toxref  = 8e-009
+dlcig   = 1.5e-007
+vth0    = 0.72046743
+wvth0   = -5.0747914e-009
+k1      = 0.79064
+k2      = -0.00621789
+wk2     = -1.6843437e-009
+k3      = 0
+k3b     = 0
+w0      = 5e-007
+dvt0    = 0
+dvt1    = 0.53
+dvt2    = 0
+dvt0w   = 0
+dvt1w   = 0
+dvt2w   = 0
+dsub    = 0.5
+minv    = -0.25
+voffl   = 0
+dvtp0   = 0
+dvtp1   = 0
+lpe0    = 1.1e-007
+lpeb    = 0
+vbm     = -3
+xj      = 1e-007
+ngate   = 6e+019
+ndep    = 3e+017
+nsd     = 1e+020
+phin    = 0.07
+cdsc    = 0
+cdscb   = 0
+cdscd   = 0
+cit     = 0
+voff    = -0.12066
+nfactor = 1
+eta0    = 0.75
+etab    = -0.32
+u0      = 0.036327357
+wu0     = -1.1037279e-009
+ua      = -7.6631329e-010
+wua     = -6.0567557e-018
+ub      = 2.9923729e-018
+wub     = -1.5499324e-025
+uc      = 9.5953471e-011
+wuc     = -7.7213816e-018
+eu      = 1.67
+vsat    = 75000
+a0      = 1.1588
+ags     = 0.29695757
+wags    = -8.3977586e-009
+a1      = 0
+a2      = 1
+b0      = 0
+b1      = 0
+keta    = -0.024795
+dwg     = 0
+dwb     = 0
+pclm    = 0.22973971
+wpclm   = -1.3700366e-008
+pdiblc1 = 0.39
+pdiblc2 = 0.000817
+pdiblcb = 0.2
+drout   = 0.56
+pvag    = 0
+delta   = 0.003
+pscbe1  = 6.6469e+008
+pscbe2  = 1.638e-005
+fprout  = 0
+pdits   = 0
+pditsd  = 0
+pditsl  = 0
+rsh     = 7
+rdsw    = 530
+rdswmin = 50
+rdwmin  = 0
+rswmin  = 0
+prwg    = 0
+prwb    = 0
+wr      = 1
+alpha0  = 8.0592e-005
+alpha1  = 0
+beta0   = 23.6712
+wbeta0  = 1.86966e-007
+agidl   = 1.3268e-010
+bgidl   = 1.8961e+009
+cgidl   = 0.5
+egidl   = 0.8
+cgso    = 1.23e-010
+cgdo    = 1.23e-010
+cgbo    = 1e-013
+cgdl    = 1.1e-010
+cgsl    = 1.1e-010
+clc     = 1e-007
+cle     = 0.6
+cf      = 0
+ckappas = 0.6
+ckappad = 0.6
+vfbcv   = -1
+acde    = 0.6
+moin    = 15
+noff    = 2
+voffcv  = 0.005
+tvoff   = 0.001
+ltvoff  = 0
+wtvoff  = 0
+ptvoff  = 0
+kt1     = -0.3443
+kt1l    = 0
+kt2     = -0.022421429
+wkt2    = 7.8557143e-010
+ute     = -1.6842857
+wute    = 1.5711429e-007
+ua1     = 1.675e-009
+ub1     = -3.4676e-018
+wub1    = 4.45419e-025
+uc1     = -5.6e-011
+prt     = 0
+at      = 23000
+fnoimod = 1
+tnoimod = 0
+em      = 4.1e+007
+ef      = 0.95
+noia    = nmos_3p3_noia
+noib    = nmos_3p3_noib
+noic    = nmos_3p3_noic
+ntnoi   = 1
+jss     = 2.2959e-007
+jsws    = 2.1207e-013
+jswgs   = 0
+njs     = 1.01
+ijthsfwd= 0.1
+ijthsrev= 0.1
+pbs     = 0.70172
+cjs     = 0.00096797
+mjs     = 0.32071
+pbsws   = 0.8062
+cjsws   = 1.5663e-010
+mjsws   = 0.1
+pbswgs  = 0.74743
+cjswgs  = 5.9903e-010
+mjswgs  = 0.32059
+tpb     = 0.0018129
+tcj     = 0.0009438
+tpbsw   = 5e-005
+tcjsw   = 0.00060474
+tpbswg  = 0.0016872
+tcjswg  = 0.001
+xtis    = 3
+dmcg    = 1.5e-007
+saref   = 4.4e-007
+sbref   = 4.4e-007
+kvth0   = 0
+ku0     = 0
+kvsat   = 0

.model  nmos_3p3.8  nmos
+level = 54
+lmin    = 2.8e-007
+lmax    = 5e-007
+wmin    = 1.2e-006
+wmax    = 1e-005
+version = 4.5
+binunit = 2
+paramchk= 1
+mobmod  = 0
+capmod  = 2
+igcmod  = 0
+igbmod  = 0
+geomod  = 0
+diomod  = 1
+rdsmod  = 0
+rbodymod= 0
+rgatemod= 0
+permod  = 1
+acnqsmod= 0
+trnqsmod= 0
+tnom    = 25
+toxe    = 8.4e-009
+toxp    = 8.4e-009
+toxm    = 8e-009
+epsrox  = 3.9
+wint    = 1e-008
+lint    = 0
+ll      = 0
+wl      = 0
+lln     = 1
+wln     = 1
+lw      = 0
+ww      = 0
+lwn     = 1
+wwn     = 1
+lwl     = 0
+wwl     = 0
+xl      = 1.5e-008
+xw      = -1e-008
+dlc     = 0
+dwc     = 0
+xpart   = 0
+toxref  = 8e-009
+dlcig   = 1.5e-007
+vth0    = 0.83011576
+lvth0   = -6.047942e-008
+wvth0   = -5.9127366e-008
+pvth0   = 1.9616751e-014
+k1      = 0.96085697
+lk1     = -1.0374519e-007
+wk1     = 1.0806903e-008
+pk1     = -5.5655552e-015
+k2      = 0.017201346
+lk2     = -3.2812362e-008
+wk2     = 1.983753e-008
+pk2     = -5.8520714e-015
+k3      = 0
+k3b     = 0
+w0      = 5e-007
+dvt0    = 0
+dvt1    = 0.53
+dvt2    = 0
+dvt0w   = 0
+dvt1w   = 0
+dvt2w   = 0
+dsub    = 0.5
+minv    = -0.25
+voffl   = 0
+dvtp0   = 0
+dvtp1   = 0
+lpe0    = 1.1e-007
+lpeb    = 0
+vbm     = -3
+xj      = 1e-007
+ngate   = 6e+019
+ndep    = 3e+017
+nsd     = 1e+020
+phin    = 0.07
+cdsc    = 0
+cdscb   = 0
+cdscd   = 0
+cit     = 0
+voff    = -0.1242889
+lvoff   = 7.3910414e-010
+wvoff   = 3.618017e-008
+pvoff   = -7.3688683e-015
+nfactor = 1
+eta0    = 0.75
+etab    = -0.32
+u0      = 0.046865722
+lu0     = 1.8889394e-010
+wu0     = -1.6554457e-008
+pu0     = 4.5128597e-015
+ua      = -6.8932314e-010
+lua     = 2.7643655e-016
+wua     = 3.7260197e-017
+pua     = 1.8780087e-022
+ub      = 3.8304076e-018
+lub     = -3.6068e-025
+wub     = -1.6580185e-024
+pub     = 4.5403213e-032
+uc      = 3.0152161e-010
+luc     = -7.3826884e-017
+wuc     = -1.6193132e-016
+puc     = 3.4675789e-023
+eu      = 1.67
+vsat    = 75713.12
+lvsat   = -0.00036725671
+wvsat   = -0.0071098048
+pvsat   = 3.6615494e-009
+a0      = 0.10371296
+la0     = -8.7702159e-010
+ags     = 0.26715255
+lags    = 3.5482186e-008
+wags    = 1.3851677e-007
+pags    = -7.1336137e-014
+a1      = 0
+a2      = 1
+b0      = 0
+b1      = 0
+keta    = -0.12745025
+lketa   = 3.247088e-008
+wketa   = -4.3512005e-009
+pketa   = 2.2408683e-015
+dwg     = 0
+dwb     = 0
+pclm    = 0.2060622
+lpclm   = -1.0687288e-008
+wpclm   = 2.839894e-007
+ppclm   = -6.302442e-014
+pdiblc1 = 0.39
+pdiblc2 = 0.003171
+pdiblcb = 0.2
+drout   = 0.56
+pvag    = 0
+delta   = 0.0032954546
+ldelta  = 3.4528409e-009
+pscbe1  = 6.6469e+008
+pscbe2  = 1.638e-005
+fprout  = 0
+pdits   = 0
+pditsd  = 0
+pditsl  = 0
+rsh     = 7
+rdsw    = 530
+rdswmin = 50
+rdwmin  = 0
+rswmin  = 0
+prwg    = 0
+prwb    = 0
+wr      = 1
+alpha0  = 2.622667e-006
+lalpha0 = -2.7607448e-013
+walpha0 = 1.1926697e-013
+palpha0 = -6.1422492e-020
+alpha1  = 0
+beta0   = 21.140107
+wbeta0  = -5.5938498e-007
+agidl   = 1.3268e-010
+bgidl   = 1.8961e+009
+cgidl   = 0.5
+egidl   = 0.8
+cgso    = 1.23e-010
+cgdo    = 1.23e-010
+cgbo    = 1e-013
+cgdl    = 1.1e-010
+cgsl    = 1.1e-010
+clc     = 1e-007
+cle     = 0.6
+cf      = 0
+ckappas = 0.6
+ckappad = 0.6
+vfbcv   = -1
+acde    = 0.6
+moin    = 15
+noff    = -0.73454029
+lnoff   = 1.4082882e-006
+wnoff   = 3.1994121e-006
+pnoff   = -1.6476972e-012
+voffcv  = 0.2404743
+lvoffcv = -1.2126927e-007
+wvoffcv = -2.7550493e-007
+pvoffcv = 1.4188504e-013
+tvoff   = 0.001
+ltvoff  = 0
+wtvoff  = 0
+ptvoff  = 0
+kt1     = -0.28017689
+lkt1    = -1.0927331e-008
+wkt1    = -1.2364312e-007
+pkt1    = 3.7823806e-014
+kt1l    = 0
+kt2     = -0.025545233
+lkt2    = 1.045102e-009
+wkt2    = 9.247235e-009
+pkt2    = -3.3970025e-015
+ute     = -1.5699432
+wute    = 1.9883352e-007
+ua1     = 1.675e-009
+ub1     = -5.4287188e-018
+lub1    = 5.2357491e-025
+wub1    = 2.1207614e-024
+pub1    = -3.3860178e-031
+uc1     = -2.3453481e-010
+luc1    = 5.3914751e-017
+wuc1    = 2.0888573e-016
+puc1    = -6.3080258e-023
+prt     = 0
+at      = 23000
+fnoimod = 1
+tnoimod = 0
+em      = 4.1e+007
+ef      = 0.95
+noia    = nmos_3p3_noia
+noib    = nmos_3p3_noib
+noic    = nmos_3p3_noic
+ntnoi   = 1
+jss     = 2.2959e-007
+jsws    = 2.1207e-013
+jswgs   = 0
+njs     = 1.01
+ijthsfwd= 0.1
+ijthsrev= 0.1
+pbs     = 0.70172
+cjs     = 0.00096797
+mjs     = 0.32071
+pbsws   = 0.8062
+cjsws   = 1.5663e-010
+mjsws   = 0.1
+pbswgs  = 0.74743
+cjswgs  = 5.9903e-010
+mjswgs  = 0.32059
+tpb     = 0.0018129
+tcj     = 0.0009438
+tpbsw   = 5e-005
+tcjsw   = 0.00060474
+tpbswg  = 0.0016872
+tcjswg  = 0.001
+xtis    = 3
+dmcg    = 1.5e-007
+saref   = 4.4e-007
+sbref   = 4.4e-007
+kvth0   = 0
+ku0     = 0
+kvsat   = 0

.model  nmos_3p3.9  nmos
+level = 54
+lmin    = 5e-007
+lmax    = 1.2e-006
+wmin    = 1.2e-006
+wmax    = 1e-005
+version = 4.5
+binunit = 2
+paramchk= 1
+mobmod  = 0
+capmod  = 2
+igcmod  = 0
+igbmod  = 0
+geomod  = 0
+diomod  = 1
+rdsmod  = 0
+rbodymod= 0
+rgatemod= 0
+permod  = 1
+acnqsmod= 0
+trnqsmod= 0
+tnom    = 25
+toxe    = 8.4e-009
+toxp    = 8.4e-009
+toxm    = 8e-009
+epsrox  = 3.9
+wint    = 1e-008
+lint    = 0
+ll      = 0
+wl      = 0
+lln     = 1
+wln     = 1
+lw      = 0
+ww      = 0
+lwn     = 1
+wwn     = 1
+lwl     = 0
+wwl     = 0
+xl      = 1.5e-008
+xw      = -1e-008
+dlc     = 0
+dwc     = 0
+xpart   = 0
+toxref  = 8e-009
+dlcig   = 1.5e-007
+vth0    = 0.73285729
+lvth0   = -1.0391311e-008
+wvth0   = 3.9729778e-009
+pvth0   = -1.2879926e-014
+k1      = 0.75941
+k2      = 0.017945817
+lk2     = -3.3195765e-008
+wk2     = -6.2346523e-009
+pk2     = 7.5751026e-015
+k3      = 0
+k3b     = 0
+w0      = 5e-007
+dvt0    = 0
+dvt1    = 0.53
+dvt2    = 0
+dvt0w   = 0
+dvt1w   = 0
+dvt2w   = 0
+dsub    = 0.5
+minv    = -0.25
+voffl   = 0
+dvtp0   = 0
+dvtp1   = 0
+lpe0    = 1.1e-007
+lpeb    = 0
+vbm     = -3
+xj      = 1e-007
+ngate   = 6e+019
+ndep    = 3e+017
+nsd     = 1e+020
+phin    = 0.07
+cdsc    = 0
+cdscb   = 0
+cdscd   = 0
+cit     = 0
+voff    = -0.10229638
+lvoff   = -1.0587044e-008
+wvoff   = -1.6091313e-008
+pvoff   = 1.9550945e-014
+nfactor = 1
+eta0    = 0.75
+etab    = -0.32
+u0      = 0.038348141
+lu0     = 4.5754485e-009
+wu0     = -8.387527e-009
+pu0     = 3.068906e-016
+ua      = -9.3887833e-010
+lua     = 4.0495747e-016
+wua     = -2.9569982e-016
+pua     = 3.5927528e-022
+ub      = 3.4762372e-018
+lub     = -1.7828226e-025
+wub     = -6.5000193e-025
+pub     = -4.7372533e-031
+uc      = 1.5713919e-010
+luc     = 5.3005815e-019
+wuc     = -8.4338174e-017
+puc     = -5.2846797e-024
+eu      = 1.67
+vsat    = 75000
+a0      = 0.58607632
+la0     = -2.4929415e-007
+wa0     = 4.6938374e-007
+pa0     = -2.4173263e-013
+ags     = 0.63698234
+lags    = -1.5498016e-007
+wags    = -1.6607087e-007
+pags    = 8.5526499e-014
+a1      = 0
+a2      = 1
+b0      = 0
+b1      = 0
+keta    = -0.043632179
+lketa   = -1.0695428e-008
+dwg     = 0
+dwb     = 0
+pclm    = 0.046153372
+lpclm   = 7.1665757e-008
+wpclm   = 1.7792447e-007
+ppclm   = -8.4009819e-015
+pdiblc1 = 0.39
+pdiblc2 = 0.00133635
+lpdiblc2= 9.4484475e-010
+pdiblcb = 0.2
+drout   = 0.56
+pvag    = 0
+delta   = 0.0013214286
+ldelta  = 4.4694643e-009
+pscbe1  = 6.6469e+008
+pscbe2  = 1.638e-005
+fprout  = 0
+pdits   = 0
+pditsd  = 0
+pditsl  = 0
+rsh     = 7
+rdsw    = 530
+rdswmin = 50
+rdwmin  = 0
+rswmin  = 0
+prwg    = 0
+prwb    = 0
+wr      = 1
+alpha0  = 6.7617464e-006
+lalpha0 = -2.4077004e-012
+alpha1  = 0
+beta0   = 21.042721
+lbeta0  = 5.0153484e-008
+wbeta0  = 4.1154752e-007
+pbeta0  = -5.0003024e-013
+agidl   = 1.3268e-010
+bgidl   = 1.8961e+009
+cgidl   = 0.5
+egidl   = 0.8
+cgso    = 1.23e-010
+cgdo    = 1.23e-010
+cgbo    = 1e-013
+cgdl    = 1.1e-010
+cgsl    = 1.1e-010
+clc     = 1e-007
+cle     = 0.6
+cf      = 0
+ckappas = 0.6
+ckappad = 0.6
+vfbcv   = -1
+acde    = 0.6
+moin    = 15
+noff    = 2
+voffcv  = 0.005
+tvoff   = 0.001
+ltvoff  = 0
+wtvoff  = 0
+ptvoff  = 0
+kt1     = -0.30307353
+lkt1    = 8.6443502e-010
+wkt1    = -9.2993492e-008
+pkt1    = 2.2039247e-014
+kt1l    = 0
+kt2     = -0.02178266
+lkt2    = -8.9262312e-010
+wkt2    = -5.976841e-009
+pkt2    = 4.4433966e-015
+ute     = -1.5699432
+wute    = 1.9883352e-007
+ua1     = 1.675e-009
+ub1     = -3.0159014e-018
+lub1    = -7.1902608e-025
+wub1    = 3.0598585e-025
+pub1    = 5.960076e-031
+uc1     = -1.4525572e-010
+luc1    = 7.9360174e-018
+wuc1    = 6.0235233e-017
+puc1    = 1.3474748e-023
+prt     = 0
+at      = 23000
+fnoimod = 1
+tnoimod = 0
+em      = 4.1e+007
+ef      = 0.95
+noia    = nmos_3p3_noia
+noib    = nmos_3p3_noib
+noic    = nmos_3p3_noic
+ntnoi   = 1
+jss     = 2.2959e-007
+jsws    = 2.1207e-013
+jswgs   = 0
+njs     = 1.01
+ijthsfwd= 0.1
+ijthsrev= 0.1
+pbs     = 0.70172
+cjs     = 0.00096797
+mjs     = 0.32071
+pbsws   = 0.8062
+cjsws   = 1.5663e-010
+mjsws   = 0.1
+pbswgs  = 0.74743
+cjswgs  = 5.9903e-010
+mjswgs  = 0.32059
+tpb     = 0.0018129
+tcj     = 0.0009438
+tpbsw   = 5e-005
+tcjsw   = 0.00060474
+tpbswg  = 0.0016872
+tcjswg  = 0.001
+xtis    = 3
+dmcg    = 1.5e-007
+saref   = 4.4e-007
+sbref   = 4.4e-007
+kvth0   = 0
+ku0     = 0
+kvsat   = 0

.model  nmos_3p3.10  nmos
+level = 54
+lmin    = 1.2e-006
+lmax    = 1e-005
+wmin    = 1.2e-006
+wmax    = 1e-005
+version = 4.5
+binunit = 2
+paramchk= 1
+mobmod  = 0
+capmod  = 2
+igcmod  = 0
+igbmod  = 0
+geomod  = 0
+diomod  = 1
+rdsmod  = 0
+rbodymod= 0
+rgatemod= 0
+permod  = 1
+acnqsmod= 0
+trnqsmod= 0
+tnom    = 25
+toxe    = 8.4e-009
+toxp    = 8.4e-009
+toxm    = 8e-009
+epsrox  = 3.9
+wint    = 1e-008
+lint    = 0
+ll      = 0
+wl      = 0
+lln     = 1
+wln     = 1
+lw      = 0
+ww      = 0
+lwn     = 1
+wwn     = 1
+lwl     = 0
+wwl     = 0
+xl      = 1.5e-008
+xw      = -1e-008
+dlc     = 0
+dwc     = 0
+xpart   = 0
+toxref  = 8e-009
+dlcig   = 1.5e-007
+vth0    = 0.71814741
+lvth0   = 7.4811957e-009
+wvth0   = -2.7658345e-009
+pvth0   = -4.6922687e-015
+k1      = 0.79753063
+lk1     = -4.6316563e-008
+wk1     = -3.0171481e-009
+pk1     = 3.6658349e-015
+k2      = -0.0074202574
+lk2     = -2.3759842e-009
+k3      = 0
+k3b     = 0
+w0      = 5e-007
+dvt0    = 0
+dvt1    = 0.53
+dvt2    = 0
+dvt0w   = 0
+dvt1w   = 0
+dvt2w   = 0
+dsub    = 0.5
+minv    = -0.25
+voffl   = 0
+dvtp0   = 0
+dvtp1   = 0
+lpe0    = 1.1e-007
+lpeb    = 0
+vbm     = -3
+xj      = 1e-007
+ngate   = 6e+019
+ndep    = 3e+017
+nsd     = 1e+020
+phin    = 0.07
+cdsc    = 0
+cdscb   = 0
+cdscd   = 0
+cit     = 0
+voff    = -0.12199236
+lvoff   = 1.3343565e-008
+nfactor = 1
+eta0    = 0.75
+etab    = -0.32
+u0      = 0.040486527
+lu0     = 1.9773099e-009
+wu0     = -5.9339327e-009
+pu0     = -2.6742266e-015
+ua      = -8.1101699e-010
+lua     = 2.4960595e-016
+wua     = 1.9445519e-017
+pua     = -2.3626306e-023
+ub      = 3.1890972e-018
+lub     = 1.7059289e-025
+wub     = -3.1744322e-025
+pub     = -8.7778417e-031
+uc      = 1.0423443e-010
+luc     = 6.4809343e-017
+wuc     = -1.6185636e-017
+puc     = -8.8090013e-023
+eu      = 1.67
+vsat    = 75000
+a0      = 1.1765919
+la0     = -9.6677061e-007
+wa0     = 6.7508553e-008
+pa0     = 2.4654573e-013
+ags     = 0.26693219
+lags    = 2.9463078e-007
+wags    = 4.4604535e-009
+pags    = -1.2166906e-013
+a1      = 0
+a2      = 1
+b0      = 0
+b1      = 0
+keta    = -0.020978796
+lketa   = -3.8219289e-008
+dwg     = 0
+dwb     = 0
+pclm    = 0.23361686
+lpclm   = -1.5610238e-007
+wpclm   = -2.3611051e-008
+ppclm   = 2.3646468e-013
+pdiblc1 = 0.39
+pdiblc2 = 0.00063792557
+lpdiblc2= 1.7934304e-009
+pdiblcb = 0.2
+drout   = 0.56
+pvag    = 0
+delta   = 0.0027238636
+ldelta  = 2.7655057e-009
+pscbe1  = 6.6469e+008
+pscbe2  = 1.638e-005
+fprout  = 0
+pdits   = 0
+pditsd  = 0
+pditsl  = 0
+rsh     = 7
+rdsw    = 530
+rdswmin = 50
+rdwmin  = 0
+rswmin  = 0
+prwg    = 0
+prwb    = 0
+wr      = 1
+alpha0  = 9.1059211e-005
+lalpha0 = -1.0482912e-010
+alpha1  = 0
+beta0   = 24.517146
+lbeta0  = -4.1712719e-006
+wbeta0  = -3.5904062e-007
+pbeta0  = 4.3623435e-013
+agidl   = 1.3268e-010
+bgidl   = 1.8961e+009
+cgidl   = 0.5
+egidl   = 0.8
+cgso    = 1.23e-010
+cgdo    = 1.23e-010
+cgbo    = 1e-013
+cgdl    = 1.1e-010
+cgsl    = 1.1e-010
+clc     = 1e-007
+cle     = 0.6
+cf      = 0
+ckappas = 0.6
+ckappad = 0.6
+vfbcv   = -1
+acde    = 0.6
+moin    = 15
+noff    = 2.128938
+lnoff   = -1.5665961e-007
+wnoff   = -1.508574e-007
+pnoff   = 1.8329175e-013
+voffcv  = -0.065915874
+lvoffcv = 8.6162786e-008
+wvoffcv = 8.2971572e-008
+pvoffcv = -1.0081046e-013
+tvoff   = 0.001
+ltvoff  = 0
+wtvoff  = 0
+ptvoff  = 0
+kt1     = -0.31510943
+lkt1    = 1.5488057e-008
+wkt1    = -3.0592631e-008
+pkt1    = -5.3777798e-014
+kt1l    = 0
+kt2     = -0.016808883
+lkt2    = -6.9357625e-009
+wkt2    = -5.3368725e-009
+pkt2    = 3.6658349e-015
+ute     = -1.5472465
+lute    = -2.7576491e-008
+wute    = -2.7452583e-008
+pute    = 2.7493762e-013
+ua1     = 1.6533384e-009
+lua1    = 2.6318815e-017
+wua1    = 2.5344044e-017
+pua1    = -3.0793013e-023
+ub1     = -2.1471138e-018
+lub1    = -1.774603e-024
+wub1    = -1.1253962e-024
+pub1    = 2.3351368e-030
+uc1     = -4.4578445e-011
+luc1    = -1.1438687e-016
+wuc1    = -9.8477906e-018
+puc1    = 9.8625623e-023
+prt     = 0
+at      = 23000
+fnoimod = 1
+tnoimod = 0
+em      = 4.1e+007
+ef      = 0.95
+noia    = nmos_3p3_noia
+noib    = nmos_3p3_noib
+noic    = nmos_3p3_noic
+ntnoi   = 1
+jss     = 2.2959e-007
+jsws    = 2.1207e-013
+jswgs   = 0
+njs     = 1.01
+ijthsfwd= 0.1
+ijthsrev= 0.1
+pbs     = 0.70172
+cjs     = 0.00096797
+mjs     = 0.32071
+pbsws   = 0.8062
+cjsws   = 1.5663e-010
+mjsws   = 0.1
+pbswgs  = 0.74743
+cjswgs  = 5.9903e-010
+mjswgs  = 0.32059
+tpb     = 0.0018129
+tcj     = 0.0009438
+tpbsw   = 5e-005
+tcjsw   = 0.00060474
+tpbswg  = 0.0016872
+tcjswg  = 0.001
+xtis    = 3
+dmcg    = 1.5e-007
+saref   = 4.4e-007
+sbref   = 4.4e-007
+kvth0   = 0
+ku0     = 0
+kvsat   = 0

.model  nmos_3p3.11  nmos
+level = 54
+lmin    = 1e-005
+lmax    = 5.0001e-005
+wmin    = 1.2e-006
+wmax    = 1e-005
+version = 4.5
+binunit = 2
+paramchk= 1
+mobmod  = 0
+capmod  = 2
+igcmod  = 0
+igbmod  = 0
+geomod  = 0
+diomod  = 1
+rdsmod  = 0
+rbodymod= 0
+rgatemod= 0
+permod  = 1
+acnqsmod= 0
+trnqsmod= 0
+tnom    = 25
+toxe    = 8.4e-009
+toxp    = 8.4e-009
+toxm    = 8e-009
+epsrox  = 3.9
+wint    = 1e-008
+lint    = 0
+ll      = 0
+wl      = 0
+lln     = 1
+wln     = 1
+lw      = 0
+ww      = 0
+lwn     = 1
+wwn     = 1
+lwl     = 0
+wwl     = 0
+xl      = 1.5e-008
+xw      = -1e-008
+dlc     = 0
+dwc     = 0
+xpart   = 0
+toxref  = 8e-009
+dlcig   = 1.5e-007
+vth0    = 0.71889441
+wvth0   = -3.2343586e-009
+k1      = 0.79290591
+wk1     = -2.6511136e-009
+k2      = -0.0076575
+k3      = 0
+k3b     = 0
+w0      = 5e-007
+dvt0    = 0
+dvt1    = 0.53
+dvt2    = 0
+dvt0w   = 0
+dvt1w   = 0
+dvt2w   = 0
+dsub    = 0.5
+minv    = -0.25
+voffl   = 0
+dvtp0   = 0
+dvtp1   = 0
+lpe0    = 1.1e-007
+lpeb    = 0
+vbm     = -3
+xj      = 1e-007
+ngate   = 6e+019
+ndep    = 3e+017
+nsd     = 1e+020
+phin    = 0.07
+cdsc    = 0
+cdscb   = 0
+cdscd   = 0
+cit     = 0
+voff    = -0.12066
+nfactor = 1
+eta0    = 0.75
+etab    = -0.32
+u0      = 0.040683961
+wu0     = -6.2009548e-009
+ua      = -7.8609378e-010
+wua     = 1.7086427e-017
+ub      = 3.2061309e-018
+wub     = -4.0509016e-025
+uc      = 1.1070566e-010
+wuc     = -2.4981444e-017
+eu      = 1.67
+vsat    = 75000
+a0      = 1.0800597
+wa0     = 9.2126199e-008
+ags     = 0.29635114
+wags    = -7.6882295e-009
+a1      = 0
+a2      = 1
+b0      = 0
+b1      = 0
+keta    = -0.024795
+dwg     = 0
+dwb     = 0
+pclm    = 0.21803
+pdiblc1 = 0.39
+pdiblc2 = 0.000817
+pdiblcb = 0.2
+drout   = 0.56
+pvag    = 0
+delta   = 0.003
+pscbe1  = 6.6469e+008
+pscbe2  = 1.638e-005
+fprout  = 0
+pdits   = 0
+pditsd  = 0
+pditsl  = 0
+rsh     = 7
+rdsw    = 530
+rdswmin = 50
+rdwmin  = 0
+rswmin  = 0
+prwg    = 0
+prwb    = 0
+wr      = 1
+alpha0  = 8.0592e-005
+alpha1  = 0
+beta0   = 24.100643
+wbeta0  = -3.1548252e-007
+agidl   = 1.3268e-010
+bgidl   = 1.8961e+009
+cgidl   = 0.5
+egidl   = 0.8
+cgso    = 1.23e-010
+cgdo    = 1.23e-010
+cgbo    = 1e-013
+cgdl    = 1.1e-010
+cgsl    = 1.1e-010
+clc     = 1e-007
+cle     = 0.6
+cf      = 0
+ckappas = 0.6
+ckappad = 0.6
+vfbcv   = -1
+acde    = 0.6
+moin    = 15
+noff    = 2.1132954
+wnoff   = -1.3255568e-007
+voffcv  = -0.0573125
+wvoffcv = 7.2905625e-008
+tvoff   = 0.001
+ltvoff  = 0
+wtvoff  = 0
+ptvoff  = 0
+kt1     = -0.31356294
+wkt1    = -3.5962356e-008
+kt1l    = 0
+kt2     = -0.017501421
+wkt2    = -4.9708381e-009
+ute     = -1.55
+ua1     = 1.6559664e-009
+wua1    = 2.2269354e-017
+ub1     = -2.3243083e-018
+wub1    = -8.9223229e-025
+uc1     = -5.6e-011
+prt     = 0
+at      = 23000
+fnoimod = 1
+tnoimod = 0
+em      = 4.1e+007
+ef      = 0.95
+noia    = nmos_3p3_noia
+noib    = nmos_3p3_noib
+noic    = nmos_3p3_noic
+ntnoi   = 1
+jss     = 2.2959e-007
+jsws    = 2.1207e-013
+jswgs   = 0
+njs     = 1.01
+ijthsfwd= 0.1
+ijthsrev= 0.1
+pbs     = 0.70172
+cjs     = 0.00096797
+mjs     = 0.32071
+pbsws   = 0.8062
+cjsws   = 1.5663e-010
+mjsws   = 0.1
+pbswgs  = 0.74743
+cjswgs  = 5.9903e-010
+mjswgs  = 0.32059
+tpb     = 0.0018129
+tcj     = 0.0009438
+tpbsw   = 5e-005
+tcjsw   = 0.00060474
+tpbswg  = 0.0016872
+tcjswg  = 0.001
+xtis    = 3
+dmcg    = 1.5e-007
+saref   = 4.4e-007
+sbref   = 4.4e-007
+kvth0   = 0
+ku0     = 0
+kvsat   = 0

.model  nmos_3p3.12  nmos
+level = 54
+lmin    = 2.8e-007
+lmax    = 5e-007
+wmin    = 1e-005
+wmax    = 0.000100001
+version = 4.5
+binunit = 2
+paramchk= 1
+mobmod  = 0
+capmod  = 2
+igcmod  = 0
+igbmod  = 0
+geomod  = 0
+diomod  = 1
+rdsmod  = 0
+rbodymod= 0
+rgatemod= 0
+permod  = 1
+acnqsmod= 0
+trnqsmod= 0
+tnom    = 25
+toxe    = 8.4e-009
+toxp    = 8.4e-009
+toxm    = 8e-009
+epsrox  = 3.9
+wint    = 1e-008
+lint    = 0
+ll      = 0
+wl      = 0
+lln     = 1
+wln     = 1
+lw      = 0
+ww      = 0
+lwn     = 1
+wwn     = 1
+lwl     = 0
+wwl     = 0
+xl      = 1.5e-008
+xw      = -1e-008
+dlc     = 3e-008
+dwc     = 0
+xpart   = 0
+toxref  = 8e-009
+dlcig   = 1.5e-007
+vth0    = 0.82418523
+lvth0   = -5.8511842e-008
+k1      = 0.96194091
+lk1     = -1.0430342e-007
+k2      = 0.019191068
+lk2     = -3.339933e-008
+k3      = 0
+k3b     = 0
+w0      = 5e-007
+dvt0    = 0
+dvt1    = 0.53
+dvt2    = 0
+dvt0w   = 0
+dvt1w   = 0
+dvt2w   = 0
+dsub    = 0.5
+minv    = -0.25
+voffl   = 0
+dvtp0   = 0
+dvtp1   = 0
+lpe0    = 1.1e-007
+lpeb    = 0
+vbm     = -3
+xj      = 1e-007
+ngate   = 6e+019
+ndep    = 3e+017
+nsd     = 1e+020
+phin    = 0.07
+cdsc    = 0
+cdscb   = 0
+cdscd   = 0
+cit     = 0
+voff    = -0.12066
+nfactor = 1
+eta0    = 0.75
+etab    = -0.32
+u0      = 0.045205295
+lu0     = 6.4153784e-010
+ua      = -6.8558591e-010
+lua     = 2.9527314e-016
+ub      = 3.6641068e-018
+lub     = -3.5612601e-025
+uc      = 2.8527975e-010
+luc     = -7.0348871e-017
+eu      = 1.67
+vsat    = 75000
+a0      = 0.13372839
+la0     = -1.6334972e-008
+wa0     = -2.9925391e-007
+pa0     = 1.5411576e-013
+ags     = 0.46825513
+lags    = -6.8085644e-008
+wags    = -1.866476e-006
+pags    = 9.6123512e-013
+a1      = 0
+a2      = 1
+b0      = 0
+b1      = 0
+keta    = -0.12409156
+lketa   = 3.0741152e-008
+wketa   = -3.7837384e-008
+pketa   = 1.9486253e-014
+dwg     = 0
+dwb     = 0
+pclm    = 0.23454659
+lpclm   = -1.7008694e-008
+pdiblc1 = 0.39
+pdiblc2 = 0.003171
+pdiblcb = 0.2
+drout   = 0.56
+pvag    = 0
+delta   = 0.0032954546
+ldelta  = 3.4528409e-009
+pscbe1  = 6.6469e+008
+pscbe2  = 1.638e-005
+fprout  = 0
+pdits   = 0
+pditsd  = 0
+pditsl  = 0
+rsh     = 7
+rdsw    = 530
+rdswmin = 50
+rdwmin  = 0
+rswmin  = 0
+prwg    = 0
+prwb    = 0
+wr      = 1
+alpha0  = 2.6346295e-006
+lalpha0 = -2.8223522e-013
+alpha1  = 0
+beta0   = 21.084
+agidl   = 1.3268e-010
+bgidl   = 1.8961e+009
+cgidl   = 0.5
+egidl   = 0.8
+cgso    = 2.53e-010
+cgdo    = 2.53e-010
+cgbo    = 1e-013
+cgdl    = 1.1e-010
+cgsl    = 1.1e-010
+clc     = 1e-007
+cle     = 0.6
+cf      = 0
+ckappas = 0.6
+ckappad = 0.6
+vfbcv   = -1
+acde    = 0.6
+moin    = 15
+noff    = -0.41363636
+lnoff   = 1.2430227e-006
+voffcv  = 0.21284091
+lvoffcv = -1.0703807e-007
+tvoff   = 0.001
+ltvoff  = 0
+wtvoff  = 0
+ptvoff  = 0
+kt1     = -0.29257841
+lkt1    = -7.1335693e-009
+kt1l    = 0
+kt2     = -0.024617727
+lkt2    = 7.0437954e-010
+ute     = -1.55
+ua1     = 1.675e-009
+ub1     = -5.2160045e-018
+lub1    = 4.8961284e-025
+uc1     = -2.1358339e-010
+luc1    = 4.7587744e-017
+prt     = 0
+at      = 23000
+fnoimod = 1
+tnoimod = 0
+em      = 4.1e+007
+ef      = 0.95
+noia    = nmos_3p3_noia
+noib    = nmos_3p3_noib
+noic    = nmos_3p3_noic
+ntnoi   = 1
+jss     = 2.2959e-007
+jsws    = 2.1207e-013
+jswgs   = 0
+njs     = 1.01
+ijthsfwd= 0.1
+ijthsrev= 0.1
+pbs     = 0.70172
+cjs     = 0.00096797
+mjs     = 0.32071
+pbsws   = 0.8062
+cjsws   = 1.5663e-010
+mjsws   = 0.1
+pbswgs  = 0.74743
+cjswgs  = 5.9903e-010
+mjswgs  = 0.32059
+tpb     = 0.0018129
+tcj     = 0.0009438
+tpbsw   = 5e-005
+tcjsw   = 0.00060474
+tpbswg  = 0.0016872
+tcjswg  = 0.001
+xtis    = 3
+dmcg    = 1.5e-007
+saref   = 4.4e-007
+sbref   = 4.4e-007
+kvth0   = 0
+ku0     = 0
+kvsat   = 0

.model  nmos_3p3.13  nmos
+level = 54
+lmin    = 5e-007
+lmax    = 1.2e-006
+wmin    = 1e-005
+wmax    = 0.000100001
+version = 4.5
+binunit = 2
+paramchk= 1
+mobmod  = 0
+capmod  = 2
+igcmod  = 0
+igbmod  = 0
+geomod  = 0
+diomod  = 1
+rdsmod  = 0
+rbodymod= 0
+rgatemod= 0
+permod  = 1
+acnqsmod= 0
+trnqsmod= 0
+tnom    = 25
+toxe    = 8.4e-009
+toxp    = 8.4e-009
+toxm    = 8e-009
+epsrox  = 3.9
+wint    = 1e-008
+lint    = 0
+ll      = 0
+wl      = 0
+lln     = 1
+wln     = 1
+lw      = 0
+ww      = 0
+lwn     = 1
+wwn     = 1
+lwl     = 0
+wwl     = 0
+xl      = 1.5e-008
+xw      = -1e-008
+dlc     = 0
+dwc     = 0
+xpart   = 0
+toxref  = 8e-009
+dlcig   = 1.5e-007
+vth0    = 0.73325579
+lvth0   = -1.168318e-008
+k1      = 0.75941
+k2      = 0.017320476
+lk2     = -3.2435975e-008
+k3      = 0
+k3b     = 0
+w0      = 5e-007
+dvt0    = 0
+dvt1    = 0.53
+dvt2    = 0
+dvt0w   = 0
+dvt1w   = 0
+dvt2w   = 0
+dsub    = 0.5
+minv    = -0.25
+voffl   = 0
+dvtp0   = 0
+dvtp1   = 0
+lpe0    = 1.1e-007
+lpeb    = 0
+vbm     = -3
+xj      = 1e-007
+ngate   = 6e+019
+ndep    = 3e+017
+nsd     = 1e+020
+phin    = 0.07
+cdsc    = 0
+cdscb   = 0
+cdscd   = 0
+cit     = 0
+voff    = -0.10391036
+lvoff   = -8.6260661e-009
+nfactor = 1
+eta0    = 0.75
+etab    = -0.32
+u0      = 0.037506864
+lu0     = 4.6062299e-009
+ua      = -9.6853729e-010
+lua     = 4.409931e-016
+ub      = 3.4110414e-018
+lub     = -2.2579734e-025
+uc      = 1.4868e-010
+eu      = 1.67
+vsat    = 75000
+a0      = 0.63315593
+la0     = -2.7354015e-007
+ags     = 0.62032529
+lags    = -1.4640177e-007
+a1      = 0
+a2      = 1
+b0      = 0
+b1      = 0
+keta    = -0.043632179
+lketa   = -1.0695428e-008
+dwg     = 0
+dwb     = 0
+pclm    = 0.063999357
+lpclm   = 7.0823131e-008
+pdiblc1 = 0.39
+pdiblc2 = 0.00133635
+lpdiblc2= 9.4484475e-010
+pdiblcb = 0.2
+drout   = 0.56
+pvag    = 0
+delta   = 0.0013214286
+ldelta  = 4.4694643e-009
+pscbe1  = 6.6469e+008
+pscbe2  = 1.638e-005
+fprout  = 0
+pdits   = 0
+pditsd  = 0
+pditsl  = 0
+rsh     = 7
+rdsw    = 530
+rdswmin = 50
+rdwmin  = 0
+rswmin  = 0
+prwg    = 0
+prwb    = 0
+wr      = 1
+alpha0  = 6.7617464e-006
+lalpha0 = -2.4077004e-012
+alpha1  = 0
+beta0   = 21.084
+agidl   = 1.3268e-010
+bgidl   = 1.8961e+009
+cgidl   = 0.5
+egidl   = 0.8
+cgso    = 1.23e-010
+cgdo    = 1.23e-010
+cgbo    = 1e-013
+cgdl    = 1.1e-010
+cgsl    = 1.1e-010
+clc     = 1e-007
+cle     = 0.6
+cf      = 0
+ckappas = 0.6
+ckappad = 0.6
+vfbcv   = -1
+acde    = 0.6
+moin    = 15
+noff    = 2
+voffcv  = 0.005
+tvoff   = 0.001
+ltvoff  = 0
+wtvoff  = 0
+ptvoff  = 0
+kt1     = -0.31240086
+lkt1    = 3.0749914e-009
+kt1l    = 0
+kt2     = -0.022382143
+lkt2    = -4.4694643e-010
+ute     = -1.55
+ua1     = 1.675e-009
+ub1     = -2.9852107e-018
+lub1    = -6.5924598e-025
+uc1     = -1.3921407e-010
+luc1    = 9.2875468e-018
+prt     = 0
+at      = 23000
+fnoimod = 1
+tnoimod = 0
+em      = 4.1e+007
+ef      = 0.95
+noia    = nmos_3p3_noia
+noib    = nmos_3p3_noib
+noic    = nmos_3p3_noic
+ntnoi   = 1
+jss     = 2.2959e-007
+jsws    = 2.1207e-013
+jswgs   = 0
+njs     = 1.01
+ijthsfwd= 0.1
+ijthsrev= 0.1
+pbs     = 0.70172
+cjs     = 0.00096797
+mjs     = 0.32071
+pbsws   = 0.8062
+cjsws   = 1.5663e-010
+mjsws   = 0.1
+pbswgs  = 0.74743
+cjswgs  = 5.9903e-010
+mjswgs  = 0.32059
+tpb     = 0.0018129
+tcj     = 0.0009438
+tpbsw   = 5e-005
+tcjsw   = 0.00060474
+tpbswg  = 0.0016872
+tcjswg  = 0.001
+xtis    = 3
+dmcg    = 1.5e-007
+saref   = 4.4e-007
+sbref   = 4.4e-007
+kvth0   = 0
+ku0     = 0
+kvsat   = 0

.model  nmos_3p3.14  nmos
+level = 54
+lmin    = 1.2e-006
+lmax    = 1e-005
+wmin    = 1e-005
+wmax    = 0.000100001
+version = 4.5
+binunit = 2
+paramchk= 1
+mobmod  = 0
+capmod  = 2
+igcmod  = 0
+igbmod  = 0
+geomod  = 0
+diomod  = 1
+rdsmod  = 0
+rbodymod= 0
+rgatemod= 0
+permod  = 1
+acnqsmod= 0
+trnqsmod= 0
+tnom    = 25
+toxe    = 8.4e-009
+toxp    = 8.4e-009
+toxm    = 8e-009
+epsrox  = 3.9
+wint    = 1e-008
+lint    = 0
+ll      = 0
+wl      = 0
+lln     = 1
+wln     = 1
+lw      = 0
+ww      = 0
+lwn     = 1
+wwn     = 1
+lwl     = 0
+wwl     = 0
+xl      = 1.5e-008
+xw      = -1e-008
+dlc     = 0
+dwc     = 0
+xpart   = 0
+toxref  = 8e-009
+dlcig   = 1.5e-007
+vth0    = 0.71786999
+lvth0   = 7.0105569e-009
+k1      = 0.79722801
+lk1     = -4.5948877e-008
+k2      = -0.0074202574
+lk2     = -2.3759842e-009
+k3      = 0
+k3b     = 0
+w0      = 5e-007
+dvt0    = 0
+dvt1    = 0.53
+dvt2    = 0
+dvt0w   = 0
+dvt1w   = 0
+dvt2w   = 0
+dsub    = 0.5
+minv    = -0.25
+voffl   = 0
+dvtp0   = 0
+dvtp1   = 0
+lpe0    = 1.1e-007
+lpeb    = 0
+vbm     = -3
+xj      = 1e-007
+ngate   = 6e+019
+ndep    = 3e+017
+nsd     = 1e+020
+phin    = 0.07
+cdsc    = 0
+cdscb   = 0
+cdscd   = 0
+cit     = 0
+voff    = -0.12199236
+lvoff   = 1.3343565e-008
+nfactor = 1
+eta0    = 0.75
+etab    = -0.32
+u0      = 0.039891348
+lu0     = 1.7090825e-009
+ua      = -8.0906659e-010
+lua     = 2.4723621e-016
+ub      = 3.1572573e-018
+lub     = 8.2550345e-026
+uc      = 1.02611e-010
+luc     = 5.5973835e-017
+eu      = 1.67
+vsat    = 75000
+a0      = 1.1833631
+la0     = -9.4204186e-007
+ags     = 0.26737957
+lags    = 2.8242727e-007
+a1      = 0
+a2      = 1
+b0      = 0
+b1      = 0
+keta    = -0.020978796
+lketa   = -3.8219289e-008
+dwg     = 0
+dwb     = 0
+pclm    = 0.23124865
+lpclm   = -1.3238476e-007
+pdiblc1 = 0.39
+pdiblc2 = 0.00063792557
+lpdiblc2= 1.7934304e-009
+pdiblcb = 0.2
+drout   = 0.56
+pvag    = 0
+delta   = 0.0027238636
+ldelta  = 2.7655057e-009
+pscbe1  = 6.6469e+008
+pscbe2  = 1.638e-005
+fprout  = 0
+pdits   = 0
+pditsd  = 0
+pditsl  = 0
+rsh     = 7
+rdsw    = 530
+rdswmin = 50
+rdwmin  = 0
+rswmin  = 0
+prwg    = 0
+prwb    = 0
+wr      = 1
+alpha0  = 9.1059211e-005
+lalpha0 = -1.0482912e-010
+alpha1  = 0
+beta0   = 24.481134
+lbeta0  = -4.1275172e-006
+agidl   = 1.3268e-010
+bgidl   = 1.8961e+009
+cgidl   = 0.5
+egidl   = 0.8
+cgso    = 1.23e-010
+cgdo    = 1.23e-010
+cgbo    = 1e-013
+cgdl    = 1.1e-010
+cgsl    = 1.1e-010
+clc     = 1e-007
+cle     = 0.6
+cf      = 0
+ckappas = 0.6
+ckappad = 0.6
+vfbcv   = -1
+acde    = 0.6
+moin    = 15
+noff    = 2.1138068
+lnoff   = -1.3827528e-007
+voffcv  = -0.05759375
+lvoffcv = 7.6051406e-008
+tvoff   = 0.001
+ltvoff  = 0
+wtvoff  = 0
+ptvoff  = 0
+kt1     = -0.3181779
+lkt1    = 1.0094096e-008
+kt1l    = 0
+kt2     = -0.017344176
+lkt2    = -6.568076e-009
+ute     = -1.55
+ua1     = 1.6558805e-009
+lua1    = 2.3230248e-017
+ub1     = -2.2599921e-018
+lub1    = -1.5403867e-024
+uc1     = -4.5566188e-011
+luc1    = -1.0449463e-016
+prt     = 0
+at      = 23000
+fnoimod = 1
+tnoimod = 0
+em      = 4.1e+007
+ef      = 0.95
+noia    = nmos_3p3_noia
+noib    = nmos_3p3_noib
+noic    = nmos_3p3_noic
+ntnoi   = 1
+jss     = 2.2959e-007
+jsws    = 2.1207e-013
+jswgs   = 0
+njs     = 1.01
+ijthsfwd= 0.1
+ijthsrev= 0.1
+pbs     = 0.70172
+cjs     = 0.00096797
+mjs     = 0.32071
+pbsws   = 0.8062
+cjsws   = 1.5663e-010
+mjsws   = 0.1
+pbswgs  = 0.74743
+cjswgs  = 5.9903e-010
+mjswgs  = 0.32059
+tpb     = 0.0018129
+tcj     = 0.0009438
+tpbsw   = 5e-005
+tcjsw   = 0.00060474
+tpbswg  = 0.0016872
+tcjswg  = 0.001
+xtis    = 3
+dmcg    = 1.5e-007
+saref   = 4.4e-007
+sbref   = 4.4e-007
+kvth0   = 0
+ku0     = 0
+kvsat   = 0

.model  nmos_3p3.15  nmos
+level = 54
+lmin    = 1e-005
+lmax    = 5.0001e-005
+wmin    = 1e-005
+wmax    = 0.000100001
+version = 4.5
+binunit = 2
+paramchk= 1
+mobmod  = 0
+capmod  = 2
+igcmod  = 0
+igbmod  = 0
+geomod  = 0
+diomod  = 1
+rdsmod  = 0
+rbodymod= 0
+rgatemod= 0
+permod  = 1
+acnqsmod= 0
+trnqsmod= 0
+tnom    = 25
+toxe    = 8.4e-009
+toxp    = 8.4e-009
+toxm    = 8e-009
+epsrox  = 3.9
+wint    = 1e-008
+lint    = 0
+ll      = 0
+wl      = 0
+lln     = 1
+wln     = 1
+lw      = 0
+ww      = 0
+lwn     = 1
+wwn     = 1
+lwl     = 0
+wwl     = 0
+xl      = 1.5e-008
+xw      = -1e-008
+dlc     = 3e-008
+dwc     = 0
+xpart   = 0
+toxref  = 8e-009
+dlcig   = 1.5e-007
+vth0    = 0.71857
+k1      = 0.79264
+k2      = -0.0076575
+k3      = 0
+k3b     = 0
+w0      = 5e-007
+dvt0    = 0
+dvt1    = 0.53
+dvt2    = 0
+dvt0w   = 0
+dvt1w   = 0
+dvt2w   = 0
+dsub    = 0.5
+minv    = -0.25
+voffl   = 0
+dvtp0   = 0
+dvtp1   = 0
+lpe0    = 1.1e-007
+lpeb    = 0
+vbm     = -3
+xj      = 1e-007
+ngate   = 6e+019
+ndep    = 3e+017
+nsd     = 1e+020
+phin    = 0.07
+cdsc    = 0
+cdscb   = 0
+cdscd   = 0
+cit     = 0
+voff    = -0.12066
+nfactor = 1
+eta0    = 0.75
+etab    = -0.32
+u0      = 0.040062
+ua      = -7.8438e-010
+ub      = 3.1655e-018
+uc      = 1.082e-010
+eu      = 1.67
+vsat    = 75000
+a0      = 1.0893
+ags     = 0.29558
+a1      = 0
+a2      = 1
+b0      = 0
+b1      = 0
+keta    = -0.024795
+dwg     = 0
+dwb     = 0
+pclm    = 0.21803
+pdiblc1 = 0.39
+pdiblc2 = 0.000817
+pdiblcb = 0.2
+drout   = 0.56
+pvag    = 0
+delta   = 0.003
+pscbe1  = 6.6469e+008
+pscbe2  = 1.638e-005
+fprout  = 0
+pdits   = 0
+pditsd  = 0
+pditsl  = 0
+rsh     = 7
+rdsw    = 530
+rdswmin = 50
+rdwmin  = 0
+rswmin  = 0
+prwg    = 0
+prwb    = 0
+wr      = 1
+alpha0  = 8.0592e-005
+alpha1  = 0
+beta0   = 24.069
+agidl   = 1.3268e-010
+bgidl   = 1.8961e+009
+cgidl   = 0.5
+egidl   = 0.8
+cgso    = 2.53e-010
+cgdo    = 2.53e-010
+cgbo    = 1e-013
+cgdl    = 1.1e-010
+cgsl    = 1.1e-010
+clc     = 1e-007
+cle     = 0.6
+cf      = 0
+ckappas = 0.6
+ckappad = 0.6
+vfbcv   = -1
+acde    = 0.6
+moin    = 15
+noff    = 2.1
+voffcv  = -0.05
+tvoff   = 0.001
+ltvoff  = 0
+wtvoff  = 0
+ptvoff  = 0
+kt1     = -0.31717
+kt1l    = 0
+kt2     = -0.018
+ute     = -1.55
+ua1     = 1.6582e-009
+ub1     = -2.4138e-018
+uc1     = -5.6e-011
+prt     = 0
+at      = 23000
+fnoimod = 1
+tnoimod = 0
+em      = 4.1e+007
+ef      = 0.95
+noia    = nmos_3p3_noia
+noib    = nmos_3p3_noib
+noic    = nmos_3p3_noic
+ntnoi   = 1
+jss     = 2.2959e-007
+jsws    = 2.1207e-013
+jswgs   = 0
+njs     = 1.01
+ijthsfwd= 0.1
+ijthsrev= 0.1
+pbs     = 0.70172
+cjs     = 0.00096797
+mjs     = 0.32071
+pbsws   = 0.8062
+cjsws   = 1.5663e-010
+mjsws   = 0.1
+pbswgs  = 0.74743
+cjswgs  = 5.9903e-010
+mjswgs  = 0.32059
+tpb     = 0.0018129
+tcj     = 0.0009438
+tpbsw   = 5e-005
+tcjsw   = 0.00060474
+tpbswg  = 0.0016872
+tcjswg  = 0.001
+xtis    = 3
+dmcg    = 1.5e-007
+saref   = 4.4e-007
+sbref   = 4.4e-007
+kvth0   = 0
+ku0     = 0
+kvsat   = 0

.model  pmos_3p3.0  pmos
+level = 54
+lmin    = 2.8e-007
+lmax    = 5e-007
+wmin    = 2.2e-007
+wmax    = 5e-007
+version = 4.5
+binunit = 2
+paramchk= 1
+mobmod  = 0
+capmod  = 2
+igcmod  = 0
+igbmod  = 0
+geomod  = 0
+diomod  = 1
+rdsmod  = 0
+rbodymod= 0
+rgatemod= 0
+permod  = 1
+acnqsmod= 0
+trnqsmod= 0
+tnom    = 25
+toxe    = 7.5e-009
+toxp    = 7.5e-009
+toxm    = 7.9e-009
+epsrox  = 3.9
+wint    = -1e-008
+lint    = 0
+ll      = 0
+wl      = 0
+lln     = 1
+wln     = 1
+lw      = 0
+ww      = 0
+lwn     = 1
+wwn     = 1
+lwl     = 0
+wwl     = 0
+xl      = -1.2e-008
+xw      = 1e-008
+dlc     = -8e-009
+dwc     = 0
+xpart   = 0
+toxref  = 7.9e-009
+dlcig   = 1.5e-007
+vth0    = -0.67663617
+lvth0   = -7.3534153e-009
+wvth0   = 4.7732695e-009
+pvth0   = 2.3377109e-015
+k1      = 0.8647782
+lk1     = 6.1568267e-009
+wk1     = 6.9370633e-008
+pk1     = -2.0803095e-014
+k2      = 0.028918855
+lk2     = -2.3507638e-008
+wk2     = -2.2539936e-008
+pk2     = 3.3878523e-015
+k3      = 0
+k3b     = 0
+w0      = 2.5e-006
+dvt0    = 2.8985
+dvt1    = 0.23999
+dvt2    = -0.016
+dvt0w   = 0
+dvt1w   = 5300000
+dvt2w   = -0.032
+dsub    = 0.3659
+minv    = -0.1
+voffl   = 0
+dvtp0   = 0
+dvtp1   = 0
+lpe0    = 3.2493e-008
+lpeb    = 0
+vbm     = -3
+xj      = 1e-007
+ngate   = 6e+019
+ndep    = 5.6e+017
+nsd     = 1e+020
+phin    = 0
+cdsc    = 0.00024
+cdscb   = 0
+cdscd   = 0
+cit     = 0
+voff    = -0.094667623
+lvoff   = -1.5583678e-009
+wvoff   = -1.6924896e-009
+pvoff   = 8.2593493e-016
+nfactor = 0.8
+eta0    = 0.2541
+etab    = -0.15284
+vfb     = 0
+u0      = 0.0078719299
+lu0     = 2.3274457e-009
+wu0     = 5.9859026e-010
+pu0     = -5.221169e-016
+ua      = 8.7644416e-011
+lua     = 9.8467082e-016
+wua     = -1.3940377e-017
+pua     = -1.9023228e-022
+ub      = 6.5842379e-019
+lub     = -1.3426634e-025
+wub     = -5.017448e-027
+pub     = 1.3446761e-033
+uc      = 8.863003e-011
+luc     = 8.2624703e-018
+wuc     = -1.4595908e-017
+puc     = -4.4377124e-024
+eu      = 1.67
+vsat    = 94000
+a0      = 1.0088763
+la0     = -1.9069135e-007
+wa0     = 1.154901e-008
+pa0     = -2.7146703e-015
+ags     = 0.20174918
+lags    = 9.8918351e-008
+wags    = -2.5751203e-008
+pags    = -1.198112e-014
+a1      = 0
+a2      = 0.99
+b0      = 0
+b1      = 0
+keta    = -0.065134512
+lketa   = 7.447618e-009
+wketa   = -7.4415355e-009
+pketa   = 3.6314694e-015
+dwg     = 0
+dwb     = 0
+pclm    = 0.35995623
+lpclm   = 6.5671827e-008
+wpclm   = 3.1666898e-008
+ppclm   = 6.4870775e-015
+pdiblc1 = 0.1484
+pdiblc2 = 0.00073695
+pdiblcb = 0
+drout   = 0.56
+pvag    = 0
+delta   = 0.01
+pscbe1  = 6.7448e+008
+pscbe2  = 1e-005
+fprout  = 0
+pdits   = 0
+pditsd  = 0
+pditsl  = 0
+rsh     = 7
+rdsw    = 466
+rdswmin = 20
+prwg    = 0
+prwb    = 0
+alpha0  = 1.1235927e-005
+lalpha0 = -2.8123501e-012
+walpha0 = -1.0380713e-013
+palpha0 = 6.3405134e-020
+alpha1  = 0
+beta0   = 39.445349
+lbeta0  = -3.3940359e-006
+wbeta0  = 2.3377646e-007
+pbeta0  = 1.1730752e-013
+agidl   = 1.5908e-011
+bgidl   = 1.3902e+009
+cgidl   = 7.5
+egidl   = 0.1009
+cgso    = 1.116e-010
+cgdo    = 1.116e-010
+cgbo    = 1e-013
+cgdl    = 3.6e-011
+cgsl    = 3.6e-011
+clc     = 1e-007
+cle     = 0.6
+cf      = 0
+ckappas = 0.6
+ckappad = 0.6
+vfbcv   = -1
+acde    = 1
+moin    = 15
+noff    = 2.4
+voffcv  = -0.16
+tvoff   = 0.0032
+ltvoff  = 0
+wtvoff  = 0
+ptvoff  = 0
+kt1     = -0.28422543
+lkt1    = -1.5068185e-008
+wkt1    = -1.1684779e-008
+pkt1    = 1.9241808e-015
+kt1l    = 0
+kt2     = -0.013066
+ute     = -1
+ua1     = 1.1573864e-009
+lua1    = 1.6719545e-016
+wua1    = 1.8158523e-016
+pua1    = -8.8613591e-023
+ub1     = -2.1477044e-018
+lub1    = -6.4044033e-025
+wub1    = -1.3505708e-025
+pub1    = 1.4828008e-031
+uc1     = -2.5233764e-010
+luc1    = 5.5767486e-017
+wuc1    = 4.2084409e-017
+puc1    = -1.3941872e-023
+prt     = 0
+at      = 12000
+fnoimod = 1
+tnoimod = 0
+em      = 4.1e+007
+ef      = 1.12
+noia    = pmos_3p3_noia
+noib    = pmos_3p3_noib
+noic    = pmos_3p3_noic
+ntnoi   = 1
+jss     = 1.653e-007
+jsws    = 2.1207e-013
+jswgs   = 0
+njs     = 1
+ijthsfwd= 0.1
+ijthsrev= 0.1
+jtss    = 1e-011
+jtssws  = 1e-011
+jtsswgs = 1e-011
+njts    = 20
+njtssw  = 20
+njtsswg = 20
+vtss    = 10
+vtssws  = 10
+vtsswgs = 10
+pbs     = 0.69939
+cjs     = 0.00094344
+mjs     = 0.32084
+pbsws   = 0.8022
+cjsws   = 1.5078e-010
+mjsws   = 0.05
+pbswgs  = 0.65
+cjswgs  = 4.794e-010
+mjswgs  = 0.21964
+tpb     = 0.0016906
+tcj     = 0.00099187
+tpbsw   = 0.0052
+tcjsw   = 0.00063483
+tpbswg  = 0.000744
+tcjswg  = 0.000932
+xtis    = 3
+dmcg    = 1.5e-007
+saref   = 4.4e-007
+sbref   = 4.4e-007
+kvth0   = 0
+ku0     = 0
+kvsat   = 0

.model  pmos_3p3.1  pmos
+level = 54
+lmin    = 5e-007
+lmax    = 1.2e-006
+wmin    = 2.2e-007
+wmax    = 5e-007
+version = 4.5
+binunit = 2
+paramchk= 1
+mobmod  = 0
+capmod  = 2
+igcmod  = 0
+igbmod  = 0
+geomod  = 0
+diomod  = 1
+rdsmod  = 0
+rbodymod= 0
+rgatemod= 0
+permod  = 1
+acnqsmod= 0
+trnqsmod= 0
+tnom    = 25
+toxe    = 7.5e-009
+toxp    = 7.5e-009
+toxm    = 7.9e-009
+epsrox  = 3.9
+wint    = -1e-008
+lint    = 0
+ll      = 0
+wl      = 0
+lln     = 1
+wln     = 1
+lw      = 0
+ww      = 0
+lwn     = 1
+wwn     = 1
+lwl     = 0
+wwl     = 0
+xl      = -1.2e-008
+xw      = 1e-008
+dlc     = -8e-009
+dwc     = 0
+xpart   = 0
+toxref  = 7.9e-009
+dlcig   = 1.5e-007
+vth0    = -0.70748201
+lvth0   = 7.6993553e-009
+wvth0   = 6.367274e-009
+pvth0   = 1.5598367e-015
+k1      = 1.0117326
+lk1     = -6.5556919e-008
+wk1     = -1.8642534e-008
+pk1     = 2.214733e-014
+k2      = -0.018588529
+lk2     = -3.2403549e-010
+wk2     = -2.8080536e-009
+pk2     = -6.2413065e-015
+k3      = 0
+k3b     = 0
+w0      = 2.5e-006
+dvt0    = 2.8985
+dvt1    = 0.23999
+dvt2    = -0.016
+dvt0w   = 0
+dvt1w   = 5300000
+dvt2w   = -0.032
+dsub    = 0.3659
+minv    = -0.1
+voffl   = 0
+dvtp0   = 0
+dvtp1   = 0
+lpe0    = 3.2493e-008
+lpeb    = 0
+vbm     = -3
+xj      = 1e-007
+ngate   = 6e+019
+ndep    = 5.6e+017
+nsd     = 1e+020
+phin    = 0
+cdsc    = 0.00024
+cdscb   = 0
+cdscd   = 0
+cit     = 0
+voff    = -0.12338433
+lvoff   = 1.2455386e-008
+nfactor = 0.8
+eta0    = 0.2541
+etab    = -0.15284
+vfb     = 0
+u0      = 0.010331202
+lu0     = 1.1273211e-009
+wu0     = -2.6339567e-010
+pu0     = -1.0146777e-016
+ua      = 3.9172068e-010
+lua     = 8.3628161e-016
+wua     = -4.9371285e-017
+pua     = -1.72942e-022
+ub      = 1.0960127e-018
+lub     = -3.4780972e-025
+wub     = -2.0220479e-025
+pub     = 9.7572098e-032
+uc      = -1.1491615e-011
+luc     = 5.7121833e-017
+wuc     = -8.0009433e-018
+puc     = -7.6560549e-024
+eu      = 1.67
+vsat    = 94000
+a0      = 1.1426483
+la0     = -2.5597206e-007
+wa0     = 4.0977761e-008
+pa0     = -1.7075901e-014
+ags     = 0.19126654
+lags    = 1.0403388e-007
+wags    = 1.4058737e-008
+pags    = -3.1408371e-014
+a1      = 0
+a2      = 0.99
+b0      = 0
+b1      = 0
+keta    = -0.0053639133
+lketa   = -2.1720434e-008
+wketa   = -2.3169788e-009
+pketa   = 1.1306857e-015
+dwg     = 0
+dwb     = 0
+pclm    = 0.25217946
+lpclm   = 1.1826689e-007
+wpclm   = 9.0167278e-008
+ppclm   = -2.2061108e-014
+pdiblc1 = 0.1484
+pdiblc2 = 0.00025119377
+lpdiblc2= 2.3704904e-010
+pdiblcb = 0
+drout   = 0.56
+pvag    = 0
+delta   = 0.01
+pscbe1  = 6.7448e+008
+pscbe2  = 1e-005
+fprout  = 0
+pdits   = 0
+pditsd  = 0
+pditsl  = 0
+rsh     = 7
+rdsw    = 466
+rdswmin = 20
+prwg    = 0
+prwb    = 0
+alpha0  = 7.4423186e-005
+lalpha0 = -3.3647732e-011
+walpha0 = 5.050231e-012
+palpha0 = -2.4517655e-018
+alpha1  = 0
+beta0   = 42.301722
+lbeta0  = -4.787946e-006
+wbeta0  = 2.9506668e-007
+pbeta0  = 8.7397887e-014
+agidl   = 1.5908e-011
+bgidl   = 1.3902e+009
+cgidl   = 7.5
+egidl   = 0.1009
+cgso    = 1.116e-010
+cgdo    = 1.116e-010
+cgbo    = 1e-013
+cgdl    = 3.6e-011
+cgsl    = 3.6e-011
+clc     = 1e-007
+cle     = 0.6
+cf      = 0
+ckappas = 0.6
+ckappad = 0.6
+vfbcv   = -1
+acde    = 1
+moin    = 15
+noff    = 2.4
+voffcv  = -0.16
+tvoff   = 0.0032
+ltvoff  = 0
+wtvoff  = 0
+ptvoff  = 0
+kt1     = -0.30910467
+lkt1    = -2.9271156e-009
+wkt1    = 2.6245925e-008
+pkt1    = -1.6586003e-014
+kt1l    = 0
+kt2     = -0.013066
+ute     = -1
+ua1     = 1.5e-009
+ub1     = -2.2487222e-018
+lub1    = -5.9114366e-025
+wub1    = -3.3106883e-026
+pub1    = 9.852838e-032
+uc1     = -7.6682222e-011
+luc1    = -2.9952355e-017
+wuc1    = 6.6740899e-018
+puc1    = 3.3383641e-024
+prt     = 0
+at      = 12000
+fnoimod = 1
+tnoimod = 0
+em      = 4.1e+007
+ef      = 1.12
+noia    = pmos_3p3_noia
+noib    = pmos_3p3_noib
+noic    = pmos_3p3_noic
+ntnoi   = 1
+jss     = 1.653e-007
+jsws    = 2.1207e-013
+jswgs   = 0
+njs     = 1
+ijthsfwd= 0.1
+ijthsrev= 0.1
+jtss    = 1e-011
+jtssws  = 1e-011
+jtsswgs = 1e-011
+njts    = 20
+njtssw  = 20
+njtsswg = 20
+vtss    = 10
+vtssws  = 10
+vtsswgs = 10
+pbs     = 0.69939
+cjs     = 0.00094344
+mjs     = 0.32084
+pbsws   = 0.8022
+cjsws   = 1.5078e-010
+mjsws   = 0.05
+pbswgs  = 0.65
+cjswgs  = 4.794e-010
+mjswgs  = 0.21964
+tpb     = 0.0016906
+tcj     = 0.00099187
+tpbsw   = 0.0052
+tcjsw   = 0.00063483
+tpbswg  = 0.000744
+tcjswg  = 0.000932
+xtis    = 3
+dmcg    = 1.5e-007
+saref   = 4.4e-007
+sbref   = 4.4e-007
+kvth0   = 0
+ku0     = 0
+kvsat   = 0

.model  pmos_3p3.2  pmos
+level = 54
+lmin    = 1.2e-006
+lmax    = 1e-005
+wmin    = 2.2e-007
+wmax    = 5e-007
+version = 4.5
+binunit = 2
+paramchk= 1
+mobmod  = 0
+capmod  = 2
+igcmod  = 0
+igbmod  = 0
+geomod  = 0
+diomod  = 1
+rdsmod  = 0
+rbodymod= 0
+rgatemod= 0
+permod  = 1
+acnqsmod= 0
+trnqsmod= 0
+tnom    = 25
+toxe    = 7.5e-009
+toxp    = 7.5e-009
+toxm    = 7.9e-009
+epsrox  = 3.9
+wint    = -1e-008
+lint    = 0
+ll      = 0
+wl      = 0
+lln     = 1
+wln     = 1
+lw      = 0
+ww      = 0
+lwn     = 1
+wwn     = 1
+lwl     = 0
+wwl     = 0
+xl      = -1.2e-008
+xw      = 1e-008
+dlc     = -8e-009
+dwc     = 0
+xpart   = 0
+toxref  = 7.9e-009
+dlcig   = 1.5e-007
+vth0    = -0.6927634
+lvth0   = -9.7863494e-009
+wvth0   = 3.9098384e-009
+pvth0   = 4.4792702e-015
+k1      = 0.95248832
+lk1     = 4.8252741e-009
+wk1     = 3.2440732e-008
+pk1     = -3.853959e-014
+k2      = -0.0097979054
+lk2     = -1.0767296e-008
+wk2     = -1.5975284e-008
+pk2     = 9.4013629e-015
+k3      = 0
+k3b     = 0
+w0      = 2.5e-006
+dvt0    = 2.8985
+dvt1    = 0.23999
+dvt2    = -0.016
+dvt0w   = 0
+dvt1w   = 5300000
+dvt2w   = -0.032
+dsub    = 0.3659
+minv    = -0.1
+voffl   = 0
+dvtp0   = 0
+dvtp1   = 0
+lpe0    = 3.2493e-008
+lpeb    = 0
+vbm     = -3
+xj      = 1e-007
+ngate   = 6e+019
+ndep    = 5.6e+017
+nsd     = 1e+020
+phin    = 0
+cdsc    = 0.00024
+cdscb   = 0
+cdscd   = 0
+cit     = 0
+voff    = -0.097813945
+lvoff   = -1.7922234e-008
+wvoff   = 1.0511012e-009
+pvoff   = -1.2487082e-015
+nfactor = 0.8
+eta0    = 0.2541
+etab    = -0.15284
+vfb     = 0
+u0      = 0.0087371575
+lu0     = 3.0210454e-009
+wu0     = 2.316895e-010
+pu0     = -6.8962895e-016
+ua      = 4.0327941e-010
+lua     = 8.2254984e-016
+wua     = -5.6078614e-017
+pua     = -1.6497369e-022
+ub      = 8.6053432e-019
+lub     = -6.8061407e-026
+wub     = -1.1643187e-025
+pub     = -4.3261328e-033
+uc      = -4.4147189e-011
+luc     = 9.5916655e-017
+wuc     = 1.9501336e-018
+puc     = -1.9477934e-023
+eu      = 1.67
+vsat    = 94000
+a0      = 1.2624812
+la0     = -3.983336e-007
+wa0     = -3.5915545e-009
+pa0     = 3.5872446e-014
+ags     = 0.1574043
+lags    = 1.4426221e-007
+wags    = 7.5813661e-010
+pags    = -1.5607258e-014
+a1      = 0
+a2      = 0.99
+b0      = 0
+b1      = 0
+keta    = 8.6249554e-005
+lketa   = -2.8195228e-008
+wketa   = -3.6739399e-009
+pketa   = 2.7427554e-015
+dwg     = 0
+dwb     = 0
+pclm    = 0.32107112
+lpclm   = 3.6423596e-008
+wpclm   = 5.3623696e-009
+ppclm   = 7.8687123e-014
+pdiblc1 = 0.1484
+pdiblc2 = 7.88813e-005
+lpdiblc2= 4.4175626e-010
+pdiblcb = 0
+drout   = 0.56
+pvag    = 0
+delta   = 0.01
+pscbe1  = 6.7448e+008
+pscbe2  = 1e-005
+fprout  = 0
+pdits   = 0
+pditsd  = 0
+pditsl  = 0
+rsh     = 7
+rdsw    = 466
+rdswmin = 20
+prwg    = 0
+prwb    = 0
+alpha0  = 0.0020546973
+lalpha0 = -2.3862134e-009
+walpha0 = 2.3605119e-011
+palpha0 = -2.4494972e-017
+alpha1  = 0
+beta0   = 44.410558
+lbeta0  = -7.2932429e-006
+wbeta0  = 4.2825183e-007
+pbeta0  = -7.0826067e-014
+agidl   = 1.5908e-011
+bgidl   = 1.3902e+009
+cgidl   = 7.5
+egidl   = 0.1009
+cgso    = 1.116e-010
+cgdo    = 1.116e-010
+cgbo    = 1e-013
+cgdl    = 3.6e-011
+cgsl    = 3.6e-011
+clc     = 1e-007
+cle     = 0.6
+cf      = 0
+ckappas = 0.6
+ckappad = 0.6
+vfbcv   = -1
+acde    = 1
+moin    = 15
+noff    = 1.946
+lnoff   = 5.39352e-007
+voffcv  = 0.0216
+lvoffcv = -2.157408e-007
+tvoff   = 0.0032
+ltvoff  = 0
+wtvoff  = 0
+ptvoff  = 0
+kt1     = -0.2677292
+lkt1    = -5.2081178e-008
+wkt1    = -1.0950226e-008
+pkt1    = 2.7603024e-014
+kt1l    = 0
+kt2     = -0.013066
+ute     = -1
+ua1     = 1.5e-009
+ub1     = -3.0352362e-018
+lub1    = 3.4323494e-025
+wub1    = 2.0295616e-025
+pub1    = -1.8191452e-031
+uc1     = -3.4663323e-011
+luc1    = -7.9870808e-017
+wuc1    = -1.3010587e-017
+puc1    = 2.672376e-023
+prt     = 0
+at      = 12000
+fnoimod = 1
+tnoimod = 0
+em      = 4.1e+007
+ef      = 1.12
+noia    = pmos_3p3_noia
+noib    = pmos_3p3_noib
+noic    = pmos_3p3_noic
+ntnoi   = 1
+jss     = 1.653e-007
+jsws    = 2.1207e-013
+jswgs   = 0
+njs     = 1
+ijthsfwd= 0.1
+ijthsrev= 0.1
+jtss    = 1e-011
+jtssws  = 1e-011
+jtsswgs = 1e-011
+njts    = 20
+njtssw  = 20
+njtsswg = 20
+vtss    = 10
+vtssws  = 10
+vtsswgs = 10
+pbs     = 0.69939
+cjs     = 0.00094344
+mjs     = 0.32084
+pbsws   = 0.8022
+cjsws   = 1.5078e-010
+mjsws   = 0.05
+pbswgs  = 0.65
+cjswgs  = 4.794e-010
+mjswgs  = 0.21964
+tpb     = 0.0016906
+tcj     = 0.00099187
+tpbsw   = 0.0052
+tcjsw   = 0.00063483
+tpbswg  = 0.000744
+tcjswg  = 0.000932
+xtis    = 3
+dmcg    = 1.5e-007
+saref   = 4.4e-007
+sbref   = 4.4e-007
+kvth0   = 0
+ku0     = 0
+kvsat   = 0

.model  pmos_3p3.3  pmos
+level = 54
+lmin    = 1e-005
+lmax    = 5.0001e-005
+wmin    = 2.2e-007
+wmax    = 5e-007
+version = 4.5
+binunit = 2
+paramchk= 1
+mobmod  = 0
+capmod  = 2
+igcmod  = 0
+igbmod  = 0
+geomod  = 0
+diomod  = 1
+rdsmod  = 0
+rbodymod= 0
+rgatemod= 0
+permod  = 1
+acnqsmod= 0
+trnqsmod= 0
+tnom    = 25
+toxe    = 7.5e-009
+toxp    = 7.5e-009
+toxm    = 7.9e-009
+epsrox  = 3.9
+wint    = -1e-008
+lint    = 0
+ll      = 0
+wl      = 0
+lln     = 1
+wln     = 1
+lw      = 0
+ww      = 0
+lwn     = 1
+wwn     = 1
+lwl     = 0
+wwl     = 0
+xl      = -1.2e-008
+xw      = 1e-008
+dlc     = -8e-009
+dwc     = 0
+xpart   = 0
+toxref  = 7.9e-009
+dlcig   = 1.5e-007
+vth0    = -0.69374321
+wvth0   = 4.3583036e-009
+k1      = 0.95297143
+wk1     = 2.8582143e-008
+k2      = -0.010875929
+wk2     = -1.5034018e-008
+k3      = 0
+k3b     = 0
+w0      = 2.5e-006
+dvt0    = 2.8985
+dvt1    = 0.23999
+dvt2    = -0.016
+dvt0w   = 0
+dvt1w   = 5300000
+dvt2w   = -0.032
+dsub    = 0.3659
+minv    = -0.1
+voffl   = 0
+dvtp0   = 0
+dvtp1   = 0
+lpe0    = 3.2493e-008
+lpeb    = 0
+vbm     = -3
+xj      = 1e-007
+ngate   = 6e+019
+ndep    = 5.6e+017
+nsd     = 1e+020
+phin    = 0
+cdsc    = 0.00024
+cdscb   = 0
+cdscd   = 0
+cit     = 0
+voff    = -0.099608321
+wvoff   = 9.2608036e-010
+nfactor = 0.8
+eta0    = 0.2541
+etab    = -0.15284
+vfb     = 0
+u0      = 0.009039625
+wu0     = 1.6264375e-010
+ua      = 4.8563321e-010
+wua     = -7.2595804e-017
+ub      = 8.5372e-019
+wub     = -1.16865e-025
+uc      = -3.4544e-011
+eu      = 1.67
+vsat    = 94000
+a0      = 1.2226
+ags     = 0.17184786
+wags    = -8.0446429e-010
+a1      = 0
+a2      = 0.99
+b0      = 0
+b1      = 0
+keta    = -0.0027366607
+wketa   = -3.3993348e-009
+dwg     = 0
+dwb     = 0
+pclm    = 0.32471786
+wpclm   = 1.3240536e-008
+pdiblc1 = 0.1484
+pdiblc2 = 0.00012311
+pdiblcb = 0
+drout   = 0.56
+pvag    = 0
+delta   = 0.01
+pscbe1  = 6.7448e+008
+pscbe2  = 1e-005
+fprout  = 0
+pdits   = 0
+pditsd  = 0
+pditsl  = 0
+rsh     = 7
+rdsw    = 466
+rdswmin = 20
+prwg    = 0
+prwb    = 0
+alpha0  = 0.0018157893
+walpha0 = 2.1152679e-011
+alpha1  = 0
+beta0   = 43.680357
+wbeta0  = 4.2116071e-007
+agidl   = 1.5908e-011
+bgidl   = 1.3902e+009
+cgidl   = 7.5
+egidl   = 0.1009
+cgso    = 1.116e-010
+cgdo    = 1.116e-010
+cgbo    = 1e-013
+cgdl    = 3.6e-011
+cgsl    = 3.6e-011
+clc     = 1e-007
+cle     = 0.6
+cf      = 0
+ckappas = 0.6
+ckappad = 0.6
+vfbcv   = -1
+acde    = 1
+moin    = 15
+noff    = 2
+voffcv  = 0
+tvoff   = 0.0032
+ltvoff  = 0
+wtvoff  = 0
+ptvoff  = 0
+kt1     = -0.27294357
+wkt1    = -8.1866071e-009
+kt1l    = 0
+kt2     = -0.013066
+ute     = -1
+ua1     = 1.5e-009
+ub1     = -3.0008714e-018
+wub1    = 1.8474286e-025
+uc1     = -4.266e-011
+wuc1    = -1.0335e-017
+prt     = 0
+at      = 12000
+fnoimod = 1
+tnoimod = 0
+em      = 4.1e+007
+ef      = 1.12
+noia    = pmos_3p3_noia
+noib    = pmos_3p3_noib
+noic    = pmos_3p3_noic
+ntnoi   = 1
+jss     = 1.653e-007
+jsws    = 2.1207e-013
+jswgs   = 0
+njs     = 1
+ijthsfwd= 0.1
+ijthsrev= 0.1
+jtss    = 1e-011
+jtssws  = 1e-011
+jtsswgs = 1e-011
+njts    = 20
+njtssw  = 20
+njtsswg = 20
+vtss    = 10
+vtssws  = 10
+vtsswgs = 10
+pbs     = 0.69939
+cjs     = 0.00094344
+mjs     = 0.32084
+pbsws   = 0.8022
+cjsws   = 1.5078e-010
+mjsws   = 0.05
+pbswgs  = 0.65
+cjswgs  = 4.794e-010
+mjswgs  = 0.21964
+tpb     = 0.0016906
+tcj     = 0.00099187
+tpbsw   = 0.0052
+tcjsw   = 0.00063483
+tpbswg  = 0.000744
+tcjswg  = 0.000932
+xtis    = 3
+dmcg    = 1.5e-007
+saref   = 4.4e-007
+sbref   = 4.4e-007
+kvth0   = 0
+ku0     = 0
+kvsat   = 0

.model  pmos_3p3.4  pmos
+level = 54
+lmin    = 2.8e-007
+lmax    = 5e-007
+wmin    = 5e-007
+wmax    = 1.2e-006
+version = 4.5
+binunit = 2
+paramchk= 1
+mobmod  = 0
+capmod  = 2
+igcmod  = 0
+igbmod  = 0
+geomod  = 0
+diomod  = 1
+rdsmod  = 0
+rbodymod= 0
+rgatemod= 0
+permod  = 1
+acnqsmod= 0
+trnqsmod= 0
+tnom    = 25
+toxe    = 7.5e-009
+toxp    = 7.5e-009
+toxm    = 7.9e-009
+epsrox  = 3.9
+wint    = -1e-008
+lint    = 0
+ll      = 0
+wl      = 0
+lln     = 1
+wln     = 1
+lw      = 0
+ww      = 0
+lwn     = 1
+wwn     = 1
+lwl     = 0
+wwl     = 0
+xl      = -1.2e-008
+xw      = 1e-008
+dlc     = -8e-009
+dwc     = 0
+xpart   = 0
+toxref  = 7.9e-009
+dlcig   = 1.5e-007
+vth0    = -0.69642702
+lvth0   = -1.9920781e-009
+wvth0   = 1.5262418e-008
+pvth0   = -5.037978e-016
+k1      = 0.99566618
+lk1     = -3.3094297e-008
+k2      = 0.012709478
+lk2     = -1.9136714e-008
+wk2     = -1.3948967e-008
+pk2     = 1.0712624e-015
+k3      = 0
+k3b     = 0
+w0      = 2.5e-006
+dvt0    = 2.8985
+dvt1    = 0.23999
+dvt2    = -0.016
+dvt0w   = 0
+dvt1w   = 5300000
+dvt2w   = -0.032
+dsub    = 0.3659
+minv    = -0.1
+voffl   = 0
+dvtp0   = 0
+dvtp1   = 0
+lpe0    = 3.2493e-008
+lpeb    = 0
+vbm     = -3
+xj      = 1e-007
+ngate   = 6e+019
+ndep    = 5.6e+017
+nsd     = 1e+020
+phin    = 0
+cdsc    = 0.00024
+cdscb   = 0
+cdscd   = 0
+cit     = 0
+voff    = -0.097861
+nfactor = 0.8
+eta0    = 0.2541
+etab    = -0.15284
+vfb     = 0
+u0      = 0.0093531893
+lu0     = 1.7194104e-009
+wu0     = -1.8647726e-010
+pu0     = -1.9985825e-016
+ua      = -1.7033143e-011
+lua     = 6.9948888e-016
+wua     = 4.1538729e-017
+pua     = -3.9085851e-023
+ub      = 1.7312067e-018
+lub     = -2.899821e-025
+wub     = -5.7359242e-025
+pub     = 8.387403e-032
+uc      = 8.7990522e-011
+luc     = 1.1729669e-017
+wuc     = -1.4256968e-017
+puc     = -6.2753276e-024
+eu      = 1.67
+vsat    = 94000
+a0      = 0.65645235
+la0     = -9.5523869e-008
+wa0     = 1.9833372e-007
+pa0     = -5.3153436e-014
+ags     = 0.21104356
+lags    = 6.5010179e-008
+wags    = -3.0677229e-008
+pags    = 5.9902112e-015
+a1      = 0
+a2      = 0.99
+b0      = 0
+b1      = 0
+keta    = -0.10320034
+lketa   = 2.0738198e-008
+wketa   = 1.2733351e-008
+pketa   = -3.4125381e-015
+dwg     = 0
+dwb     = 0
+pclm    = 0.38016331
+lpclm   = 2.5024839e-008
+wpclm   = 2.0957146e-008
+ppclm   = 2.8029981e-014
+pdiblc1 = 0.1484
+pdiblc2 = 0.00073695
+pdiblcb = 0
+drout   = 0.56
+pvag    = 0
+delta   = 0.01
+pscbe1  = 6.7448e+008
+pscbe2  = 1e-005
+fprout  = 0
+pdits   = 0
+pditsd  = 0
+pditsl  = 0
+rsh     = 7
+rdsw    = 466
+rdswmin = 20
+prwg    = 0
+prwb    = 0
+alpha0  = 1.1826838e-005
+lalpha0 = -2.8274782e-012
+walpha0 = -4.1699029e-013
+palpha0 = 7.1423027e-020
+alpha1  = 0
+beta0   = 37.990543
+lbeta0  = -2.5313328e-006
+wbeta0  = 1.0048234e-006
+pbeta0  = -3.3992511e-013
+agidl   = 1.5908e-011
+bgidl   = 1.3902e+009
+cgidl   = 7.5
+egidl   = 0.1009
+cgso    = 1.116e-010
+cgdo    = 1.116e-010
+cgbo    = 1e-013
+cgdl    = 3.6e-011
+cgsl    = 3.6e-011
+clc     = 1e-007
+cle     = 0.6
+cf      = 0
+ckappas = 0.6
+ckappad = 0.6
+vfbcv   = -1
+acde    = 1
+moin    = 15
+noff    = 2.4
+voffcv  = -0.16
+tvoff   = 0.0032
+ltvoff  = 0
+wtvoff  = 0
+ptvoff  = 0
+kt1     = -0.33242454
+lkt1    = 5.9583152e-010
+wkt1    = 1.3860749e-008
+pkt1    = -6.377748e-015
+kt1l    = 0
+kt2     = -0.013066
+ute     = -1
+ua1     = 1.99446e-009
+lua1    = -2.4129648e-016
+wua1    = -2.620638e-016
+pua1    = 1.2788713e-022
+ub1     = -2.8941809e-018
+lub1    = -2.5045136e-026
+wub1    = 2.6057544e-025
+pub1    = -1.7787938e-031
+uc1     = 4.9114909e-012
+luc1    = -3.2836296e-017
+wuc1    = -9.4257628e-017
+puc1    = 3.3018133e-023
+prt     = 0
+at      = 12000
+fnoimod = 1
+tnoimod = 0
+em      = 4.1e+007
+ef      = 1.12
+noia    = pmos_3p3_noia
+noib    = pmos_3p3_noib
+noic    = pmos_3p3_noic
+ntnoi   = 1
+jss     = 1.653e-007
+jsws    = 2.1207e-013
+jswgs   = 0
+njs     = 1
+ijthsfwd= 0.1
+ijthsrev= 0.1
+jtss    = 1e-011
+jtssws  = 1e-011
+jtsswgs = 1e-011
+njts    = 20
+njtssw  = 20
+njtsswg = 20
+vtss    = 10
+vtssws  = 10
+vtsswgs = 10
+pbs     = 0.69939
+cjs     = 0.00094344
+mjs     = 0.32084
+pbsws   = 0.8022
+cjsws   = 1.5078e-010
+mjsws   = 0.05
+pbswgs  = 0.65
+cjswgs  = 4.794e-010
+mjswgs  = 0.21964
+tpb     = 0.0016906
+tcj     = 0.00099187
+tpbsw   = 0.0052
+tcjsw   = 0.00063483
+tpbswg  = 0.000744
+tcjswg  = 0.000932
+xtis    = 3
+dmcg    = 1.5e-007
+saref   = 4.4e-007
+sbref   = 4.4e-007
+kvth0   = 0
+ku0     = 0
+kvsat   = 0

.model  pmos_3p3.5  pmos
+level = 54
+lmin    = 5e-007
+lmax    = 1.2e-006
+wmin    = 5e-007
+wmax    = 1.2e-006
+version = 4.5
+binunit = 2
+paramchk= 1
+mobmod  = 0
+capmod  = 2
+igcmod  = 0
+igbmod  = 0
+geomod  = 0
+diomod  = 1
+rdsmod  = 0
+rbodymod= 0
+rgatemod= 0
+permod  = 1
+acnqsmod= 0
+trnqsmod= 0
+tnom    = 25
+toxe    = 7.5e-009
+toxp    = 7.5e-009
+toxm    = 7.9e-009
+epsrox  = 3.9
+wint    = -1e-008
+lint    = 0
+ll      = 0
+wl      = 0
+lln     = 1
+wln     = 1
+lw      = 0
+ww      = 0
+lwn     = 1
+wwn     = 1
+lwl     = 0
+wwl     = 0
+xl      = -1.2e-008
+xw      = 1e-008
+dlc     = -8e-009
+dwc     = 0
+xpart   = 0
+toxref  = 7.9e-009
+dlcig   = 1.5e-007
+vth0    = -0.69968312
+lvth0   = -4.0309955e-010
+wvth0   = 2.2338617e-009
+pvth0   = 5.8541378e-015
+k1      = 0.976558
+lk1     = -2.3769504e-008
+k2      = -0.02687001
+lk2     = 1.7807606e-010
+wk2     = 1.5811316e-009
+pk2     = -6.5074256e-015
+k3      = 0
+k3b     = 0
+w0      = 2.5e-006
+dvt0    = 2.8985
+dvt1    = 0.23999
+dvt2    = -0.016
+dvt0w   = 0
+dvt1w   = 5300000
+dvt2w   = -0.032
+dsub    = 0.3659
+minv    = -0.1
+voffl   = 0
+dvtp0   = 0
+dvtp1   = 0
+lpe0    = 3.2493e-008
+lpeb    = 0
+vbm     = -3
+xj      = 1e-007
+ngate   = 6e+019
+ndep    = 5.6e+017
+nsd     = 1e+020
+phin    = 0
+cdsc    = 0.00024
+cdscb   = 0
+cdscd   = 0
+cit     = 0
+voff    = -0.12338433
+lvoff   = 1.2455386e-008
+nfactor = 0.8
+eta0    = 0.2541
+etab    = -0.15284
+vfb     = 0
+u0      = 0.0097778795
+lu0     = 1.5121617e-009
+wu0     = 2.9865002e-011
+pu0     = -3.0543328e-016
+ua      = 2.791058e-010
+lua     = 5.5497308e-016
+wua     = 1.0314601e-017
+pua     = -2.3848477e-023
+ub      = 1.2763808e-018
+lub     = -6.8027043e-026
+wub     = -2.9779989e-025
+pub     = -5.0712722e-032
+uc      = 9.3297873e-012
+luc     = 5.0116107e-017
+wuc     = -1.9036287e-017
+puc     = -3.9430202e-024
+eu      = 1.67
+vsat    = 94000
+a0      = 1.3375751
+la0     = -4.2791177e-007
+wa0     = -6.2333454e-008
+pa0     = 7.4052143e-014
+ags     = 0.19358686
+lags    = 7.352905e-008
+wags    = 1.2828966e-008
+pags    = -1.5240812e-014
+a1      = 0
+a2      = 0.99
+b0      = 0
+b1      = 0
+keta    = -0.0021847972
+lketa   = -2.8557385e-008
+wketa   = -4.0019103e-009
+pketa   = 4.7542695e-015
+dwg     = 0
+dwb     = 0
+pclm    = 0.55232393
+lpclm   = -5.8989544e-008
+wpclm   = -6.8909289e-008
+ppclm   = 7.1884801e-014
+pdiblc1 = 0.1484
+pdiblc2 = 0.00025119377
+lpdiblc2= 2.3704904e-010
+pdiblcb = 0
+drout   = 0.56
+pvag    = 0
+delta   = 0.01
+pscbe1  = 6.7448e+008
+pscbe2  = 1e-005
+fprout  = 0
+pdits   = 0
+pditsd  = 0
+pditsl  = 0
+rsh     = 7
+rdsw    = 466
+rdswmin = 20
+prwg    = 0
+prwb    = 0
+alpha0  = 0.00012216672
+lalpha0 = -5.6673338e-011
+walpha0 = -2.025384e-011
+palpha0 = 9.7518057e-018
+alpha1  = 0
+beta0   = 43.26392
+lbeta0  = -5.1047406e-006
+wbeta0  = -2.1489817e-007
+pbeta0  = 2.5529903e-013
+agidl   = 1.5908e-011
+bgidl   = 1.3902e+009
+cgidl   = 7.5
+egidl   = 0.1009
+cgso    = 1.116e-010
+cgdo    = 1.116e-010
+cgbo    = 1e-013
+cgdl    = 3.6e-011
+cgsl    = 3.6e-011
+clc     = 1e-007
+cle     = 0.6
+cf      = 0
+ckappas = 0.6
+ckappad = 0.6
+vfbcv   = -1
+acde    = 1
+moin    = 15
+noff    = 2.4
+voffcv  = -0.16
+tvoff   = 0.0032
+ltvoff  = 0
+wtvoff  = 0
+ptvoff  = 0
+kt1     = -0.28433818
+lkt1    = -2.2870309e-008
+wkt1    = 1.3119687e-008
+pkt1    = -6.01611e-015
+kt1l    = 0
+kt2     = -0.013066
+ute     = -1
+ua1     = 1.5e-009
+ub1     = -3.142432e-018
+lub1    = 9.6101442e-026
+wub1    = 4.4055934e-025
+pub1    = -2.6571152e-031
+uc1     = -9.9075017e-011
+luc1    = 1.790912e-017
+wuc1    = 1.8542271e-017
+puc1    = -2.2028218e-023
+prt     = 0
+at      = 12000
+fnoimod = 1
+tnoimod = 0
+em      = 4.1e+007
+ef      = 1.12
+noia    = pmos_3p3_noia
+noib    = pmos_3p3_noib
+noic    = pmos_3p3_noic
+ntnoi   = 1
+jss     = 1.653e-007
+jsws    = 2.1207e-013
+jswgs   = 0
+njs     = 1
+ijthsfwd= 0.1
+ijthsrev= 0.1
+jtss    = 1e-011
+jtssws  = 1e-011
+jtsswgs = 1e-011
+njts    = 20
+njtssw  = 20
+njtsswg = 20
+vtss    = 10
+vtssws  = 10
+vtsswgs = 10
+pbs     = 0.69939
+cjs     = 0.00094344
+mjs     = 0.32084
+pbsws   = 0.8022
+cjsws   = 1.5078e-010
+mjsws   = 0.05
+pbswgs  = 0.65
+cjswgs  = 4.794e-010
+mjswgs  = 0.21964
+tpb     = 0.0016906
+tcj     = 0.00099187
+tpbsw   = 0.0052
+tcjsw   = 0.00063483
+tpbswg  = 0.000744
+tcjswg  = 0.000932
+xtis    = 3
+dmcg    = 1.5e-007
+saref   = 4.4e-007
+sbref   = 4.4e-007
+kvth0   = 0
+ku0     = 0
+kvsat   = 0

.model  pmos_3p3.6  pmos
+level = 54
+lmin    = 1.2e-006
+lmax    = 1e-005
+wmin    = 5e-007
+wmax    = 1.2e-006
+version = 4.5
+binunit = 2
+paramchk= 1
+mobmod  = 0
+capmod  = 2
+igcmod  = 0
+igbmod  = 0
+geomod  = 0
+diomod  = 1
+rdsmod  = 0
+rbodymod= 0
+rgatemod= 0
+permod  = 1
+acnqsmod= 0
+trnqsmod= 0
+tnom    = 25
+toxe    = 7.5e-009
+toxp    = 7.5e-009
+toxm    = 7.9e-009
+epsrox  = 3.9
+wint    = -1e-008
+lint    = 0
+ll      = 0
+wl      = 0
+lln     = 1
+wln     = 1
+lw      = 0
+ww      = 0
+lwn     = 1
+wwn     = 1
+lwl     = 0
+wwl     = 0
+xl      = -1.2e-008
+xw      = 1e-008
+dlc     = -8e-009
+dwc     = 0
+xpart   = 0
+toxref  = 7.9e-009
+dlcig   = 1.5e-007
+vth0    = -0.69887884
+lvth0   = -1.3585892e-009
+wvth0   = 7.151017e-009
+pvth0   = 1.255727e-017
+k1      = 1.0136972
+lk1     = -6.7890933e-008
+k2      = -0.027348888
+lk2     = 7.4698326e-010
+wk2     = -6.6732628e-009
+pk2     = 3.2987949e-015
+k3      = 0
+k3b     = 0
+w0      = 2.5e-006
+dvt0    = 2.8985
+dvt1    = 0.23999
+dvt2    = -0.016
+dvt0w   = 0
+dvt1w   = 5300000
+dvt2w   = -0.032
+dsub    = 0.3659
+minv    = -0.1
+voffl   = 0
+dvtp0   = 0
+dvtp1   = 0
+lpe0    = 3.2493e-008
+lpeb    = 0
+vbm     = -3
+xj      = 1e-007
+ngate   = 6e+019
+ndep    = 5.6e+017
+nsd     = 1e+020
+phin    = 0
+cdsc    = 0.00024
+cdscb   = 0
+cdscd   = 0
+cit     = 0
+voff    = -0.095830735
+lvoff   = -2.0278287e-008
+nfactor = 0.8
+eta0    = 0.2541
+etab    = -0.15284
+vfb     = 0
+u0      = 0.0097384672
+lu0     = 1.5589835e-009
+wu0     = -2.9900464e-010
+pu0     = 8.5263865e-017
+ua      = 4.0443501e-010
+lua     = 4.0608197e-016
+wua     = -5.6691087e-017
+pua     = 5.575428e-023
+ub      = 1.1705395e-018
+lub     = 5.7712398e-026
+wub     = -2.8073464e-025
+pub     = -7.0986249e-032
+uc      = 1.5649873e-012
+luc     = 5.934069e-017
+wuc     = -2.227732e-017
+puc     = -9.2672655e-026
+eu      = 1.67
+vsat    = 94000
+a0      = 1.1176952
+la0     = -1.6669444e-007
+wa0     = 7.3145043e-008
+pa0     = -8.6896311e-014
+ags     = 0.16577511
+lags    = 1.0656941e-007
+wags    = -3.6783923e-009
+pags    = 4.3699301e-015
+a1      = 0
+a2      = 0.99
+b0      = 0
+b1      = 0
+keta    = -0.0068457125
+lketa   = -2.3020218e-008
+dwg     = 0
+dwb     = 0
+pclm    = 0.32904913
+lpclm   = 2.0626092e-007
+wpclm   = 1.1340266e-009
+ppclm   = -1.1326658e-014
+pdiblc1 = 0.1484
+pdiblc2 = 7.88813e-005
+lpdiblc2= 4.4175626e-010
+pdiblcb = 0
+drout   = 0.56
+pvag    = 0
+delta   = 0.01
+pscbe1  = 6.7448e+008
+pscbe2  = 1e-005
+fprout  = 0
+pdits   = 0
+pditsd  = 0
+pditsl  = 0
+rsh     = 7
+rdsw    = 466
+rdswmin = 20
+prwg    = 0
+prwb    = 0
+alpha0  = 0.0021717533
+lalpha0 = -2.4915822e-009
+walpha0 = -3.8434543e-011
+palpha0 = 3.1350481e-017
+alpha1  = 0
+beta0   = 44.341063
+lbeta0  = -6.3843867e-006
+wbeta0  = 4.6508409e-007
+pbeta0  = -5.5251989e-013
+agidl   = 1.5908e-011
+bgidl   = 1.3902e+009
+cgidl   = 7.5
+egidl   = 0.1009
+cgso    = 1.116e-010
+cgdo    = 1.116e-010
+cgbo    = 1e-013
+cgdl    = 3.6e-011
+cgsl    = 3.6e-011
+clc     = 1e-007
+cle     = 0.6
+cf      = 0
+ckappas = 0.6
+ckappad = 0.6
+vfbcv   = -1
+acde    = 1
+moin    = 15
+noff    = 1.946
+lnoff   = 5.39352e-007
+voffcv  = 0.0216
+lvoffcv = -2.157408e-007
+tvoff   = 0.0032
+ltvoff  = 0
+wtvoff  = 0
+ptvoff  = 0
+kt1     = -0.33811161
+lkt1    = 4.1012519e-008
+wkt1    = 2.6352452e-008
+pkt1    = -2.1736635e-014
+kt1l    = 0
+kt2     = -0.01697494
+lkt2    = 4.6438207e-009
+wkt2    = 2.0717382e-009
+pkt2    = -2.461225e-015
+ute     = -1
+ua1     = 1.5e-009
+ub1     = -2.5970528e-018
+lub1    = -5.5180911e-025
+wub1    = -2.928102e-026
+pub1    = 2.9245883e-031
+uc1     = -4.2459e-011
+luc1    = -4.9350708e-017
+wuc1    = -8.878878e-018
+puc1    = 1.0548107e-023
+prt     = 0
+at      = 12000
+fnoimod = 1
+tnoimod = 0
+em      = 4.1e+007
+ef      = 1.12
+noia    = pmos_3p3_noia
+noib    = pmos_3p3_noib
+noic    = pmos_3p3_noic
+ntnoi   = 1
+jss     = 1.653e-007
+jsws    = 2.1207e-013
+jswgs   = 0
+njs     = 1
+ijthsfwd= 0.1
+ijthsrev= 0.1
+jtss    = 1e-011
+jtssws  = 1e-011
+jtsswgs = 1e-011
+njts    = 20
+njtssw  = 20
+njtsswg = 20
+vtss    = 10
+vtssws  = 10
+vtsswgs = 10
+pbs     = 0.69939
+cjs     = 0.00094344
+mjs     = 0.32084
+pbsws   = 0.8022
+cjsws   = 1.5078e-010
+mjsws   = 0.05
+pbswgs  = 0.65
+cjswgs  = 4.794e-010
+mjswgs  = 0.21964
+tpb     = 0.0016906
+tcj     = 0.00099187
+tpbsw   = 0.0052
+tcjsw   = 0.00063483
+tpbswg  = 0.000744
+tcjswg  = 0.000932
+xtis    = 3
+dmcg    = 1.5e-007
+saref   = 4.4e-007
+sbref   = 4.4e-007
+kvth0   = 0
+ku0     = 0
+kvsat   = 0

.model  pmos_3p3.7  pmos
+level = 54
+lmin    = 1e-005
+lmax    = 5.0001e-005
+wmin    = 5e-007
+wmax    = 1.2e-006
+version = 4.5
+binunit = 2
+paramchk= 1
+mobmod  = 0
+capmod  = 2
+igcmod  = 0
+igbmod  = 0
+geomod  = 0
+diomod  = 1
+rdsmod  = 0
+rbodymod= 0
+rgatemod= 0
+permod  = 1
+acnqsmod= 0
+trnqsmod= 0
+tnom    = 25
+toxe    = 7.5e-009
+toxp    = 7.5e-009
+toxm    = 7.9e-009
+epsrox  = 3.9
+wint    = -1e-008
+lint    = 0
+ll      = 0
+wl      = 0
+lln     = 1
+wln     = 1
+lw      = 0
+ww      = 0
+lwn     = 1
+wwn     = 1
+lwl     = 0
+wwl     = 0
+xl      = -1.2e-008
+xw      = 1e-008
+dlc     = -8e-009
+dwc     = 0
+xpart   = 0
+toxref  = 7.9e-009
+dlcig   = 1.5e-007
+vth0    = -0.69901486
+wvth0   = 7.1522743e-009
+k1      = 1.0069
+k2      = -0.0272741
+wk2     = -6.342987e-009
+k3      = 0
+k3b     = 0
+w0      = 2.5e-006
+dvt0    = 2.8985
+dvt1    = 0.23999
+dvt2    = -0.016
+dvt0w   = 0
+dvt1w   = 5300000
+dvt2w   = -0.032
+dsub    = 0.3659
+minv    = -0.1
+voffl   = 0
+dvtp0   = 0
+dvtp1   = 0
+lpe0    = 3.2493e-008
+lpeb    = 0
+vbm     = -3
+xj      = 1e-007
+ngate   = 6e+019
+ndep    = 5.6e+017
+nsd     = 1e+020
+phin    = 0
+cdsc    = 0.00024
+cdscb   = 0
+cdscd   = 0
+cit     = 0
+voff    = -0.097861
+nfactor = 0.8
+eta0    = 0.2541
+etab    = -0.15284
+vfb     = 0
+u0      = 0.0098945529
+wu0     = -2.9046801e-010
+ua      = 4.45092e-010
+wua     = -5.110896e-017
+ub      = 1.1763177e-018
+wub     = -2.8784179e-025
+uc      = 7.5061857e-012
+wuc     = -2.2286598e-017
+eu      = 1.67
+vsat    = 94000
+a0      = 1.1010057
+wa0     = 6.4444971e-008
+ags     = 0.17644486
+wags    = -3.2408743e-009
+a1      = 0
+a2      = 0.99
+b0      = 0
+b1      = 0
+keta    = -0.0091505
+dwg     = 0
+dwb     = 0
+pclm    = 0.3497
+pdiblc1 = 0.1484
+pdiblc2 = 0.00012311
+pdiblcb = 0
+drout   = 0.56
+pvag    = 0
+delta   = 0.01
+pscbe1  = 6.7448e+008
+pscbe2  = 1e-005
+fprout  = 0
+pdits   = 0
+pditsd  = 0
+pditsl  = 0
+rsh     = 7
+rdsw    = 466
+rdswmin = 20
+prwg    = 0
+prwb    = 0
+alpha0  = 0.0019222957
+walpha0 = -3.5295729e-011
+alpha1  = 0
+beta0   = 43.701857
+wbeta0  = 4.0976571e-007
+agidl   = 1.5908e-011
+bgidl   = 1.3902e+009
+cgidl   = 7.5
+egidl   = 0.1009
+cgso    = 1.116e-010
+cgdo    = 1.116e-010
+cgbo    = 1e-013
+cgdl    = 3.6e-011
+cgsl    = 3.6e-011
+clc     = 1e-007
+cle     = 0.6
+cf      = 0
+ckappas = 0.6
+ckappad = 0.6
+vfbcv   = -1
+acde    = 1
+moin    = 15
+noff    = 2
+voffcv  = 0
+tvoff   = 0.0032
+ltvoff  = 0
+wtvoff  = 0
+ptvoff  = 0
+kt1     = -0.33400543
+wkt1    = 2.4176177e-008
+kt1l    = 0
+kt2     = -0.01651
+wkt2    = 1.82532e-009
+ute     = -1
+ua1     = 1.5e-009
+ub1     = -2.6523e-018
+uc1     = -4.74e-011
+wuc1    = -7.8228e-018
+prt     = 0
+at      = 12000
+fnoimod = 1
+tnoimod = 0
+em      = 4.1e+007
+ef      = 1.12
+noia    = pmos_3p3_noia
+noib    = pmos_3p3_noib
+noic    = pmos_3p3_noic
+ntnoi   = 1
+jss     = 1.653e-007
+jsws    = 2.1207e-013
+jswgs   = 0
+njs     = 1
+ijthsfwd= 0.1
+ijthsrev= 0.1
+jtss    = 1e-011
+jtssws  = 1e-011
+jtsswgs = 1e-011
+njts    = 20
+njtssw  = 20
+njtsswg = 20
+vtss    = 10
+vtssws  = 10
+vtsswgs = 10
+pbs     = 0.69939
+cjs     = 0.00094344
+mjs     = 0.32084
+pbsws   = 0.8022
+cjsws   = 1.5078e-010
+mjsws   = 0.05
+pbswgs  = 0.65
+cjswgs  = 4.794e-010
+mjswgs  = 0.21964
+tpb     = 0.0016906
+tcj     = 0.00099187
+tpbsw   = 0.0052
+tcjsw   = 0.00063483
+tpbswg  = 0.000744
+tcjswg  = 0.000932
+xtis    = 3
+dmcg    = 1.5e-007
+saref   = 4.4e-007
+sbref   = 4.4e-007
+kvth0   = 0
+ku0     = 0
+kvsat   = 0

.model  pmos_3p3.8  pmos
+level = 54
+lmin    = 2.8e-007
+lmax    = 5e-007
+wmin    = 1.2e-006
+wmax    = 1e-005
+version = 4.5
+binunit = 2
+paramchk= 1
+mobmod  = 0
+capmod  = 2
+igcmod  = 0
+igbmod  = 0
+geomod  = 0
+diomod  = 1
+rdsmod  = 0
+rbodymod= 0
+rgatemod= 0
+permod  = 1
+acnqsmod= 0
+trnqsmod= 0
+tnom    = 25
+toxe    = 7.5e-009
+toxp    = 7.5e-009
+toxm    = 7.9e-009
+epsrox  = 3.9
+wint    = -1e-008
+lint    = 0
+ll      = 0
+wl      = 0
+lln     = 1
+wln     = 1
+lw      = 0
+ww      = 0
+lwn     = 1
+wwn     = 1
+lwl     = 0
+wwl     = 0
+xl      = -1.2e-008
+xw      = 1e-008
+dlc     = -8e-009
+dwc     = 0
+xpart   = 0
+toxref  = 7.9e-009
+dlcig   = 1.5e-007
+vth0    = -0.68802184
+lvth0   = -8.201616e-009
+wvth0   = 4.9240544e-009
+pvth0   = 7.1339337e-015
+k1      = 0.99566618
+lk1     = -3.3094297e-008
+k2      = -0.0021980746
+lk2     = -1.6525108e-008
+wk2     = 4.3873228e-009
+pk2     = -2.1410135e-015
+k3      = 0
+k3b     = 0
+w0      = 2.5e-006
+dvt0    = 2.8985
+dvt1    = 0.23999
+dvt2    = -0.016
+dvt0w   = 0
+dvt1w   = 5300000
+dvt2w   = -0.032
+dsub    = 0.3659
+minv    = -0.1
+voffl   = 0
+dvtp0   = 0
+dvtp1   = 0
+lpe0    = 3.2493e-008
+lpeb    = 0
+vbm     = -3
+xj      = 1e-007
+ngate   = 6e+019
+ndep    = 5.6e+017
+nsd     = 1e+020
+phin    = 0
+cdsc    = 0.00024
+cdscb   = 0
+cdscd   = 0
+cit     = 0
+voff    = -0.097861
+nfactor = 0.8
+eta0    = 0.2541
+etab    = -0.15284
+vfb     = 0
+u0      = 0.011508627
+lu0     = 1.6714324e-009
+wu0     = -2.8376654e-009
+pu0     = -1.4084519e-016
+ua      = 4.0233366e-010
+lua     = 5.8911437e-016
+wua     = -4.7428243e-016
+pua     = 9.6674803e-023
+ub      = 9.3020973e-019
+lub     = 3.1000449e-026
+wub     = 4.1163392e-025
+pub     = -3.109345e-031
+uc      = 1.3317671e-010
+luc     = -6.9634759e-018
+wuc     = -6.9835979e-017
+puc     = 1.671724e-023
+eu      = 1.67
+vsat    = 94000
+a0      = 0.87540638
+la0     = -1.3755908e-007
+wa0     = -7.0979742e-008
+pa0     = -1.4501221e-015
+ags     = 0.33412543
+lags    = -2.3548078e-009
+wags    = -1.8206792e-007
+pags    = 8.8849145e-014
+a1      = 0
+a2      = 0.99
+b0      = 0
+b1      = 0
+keta    = -0.087399697
+lketa   = 1.6503627e-008
+wketa   = -6.7014347e-009
+pketa   = 1.7959845e-015
+dwg     = 0
+dwb     = 0
+pclm    = 0.32908612
+lpclm   = 4.7230737e-008
+wpclm   = 8.378208e-008
+ppclm   = 7.1672699e-016
+pdiblc1 = 0.1484
+pdiblc2 = 0.00073695
+pdiblcb = 0
+drout   = 0.56
+pvag    = 0
+delta   = 0.01
+pscbe1  = 6.7448e+008
+pscbe2  = 1e-005
+fprout  = 0
+pdits   = 0
+pditsd  = 0
+pditsl  = 0
+rsh     = 7
+rdsw    = 466
+rdswmin = 20
+prwg    = 0
+prwb    = 0
+alpha0  = 9.5254751e-006
+lalpha0 = -2.1321619e-012
+walpha0 = 2.4136865e-012
+palpha0 = -7.8381597e-019
+alpha1  = 0
+beta0   = 37.601303
+lbeta0  = -2.2168591e-006
+wbeta0  = 1.4835887e-006
+pbeta0  = -7.2672783e-013
+agidl   = 1.5908e-011
+bgidl   = 1.3902e+009
+cgidl   = 7.5
+egidl   = 0.1009
+cgso    = 1.116e-010
+cgdo    = 1.116e-010
+cgbo    = 1e-013
+cgdl    = 3.6e-011
+cgsl    = 3.6e-011
+clc     = 1e-007
+cle     = 0.6
+cf      = 0
+ckappas = 0.6
+ckappad = 0.6
+vfbcv   = -1
+acde    = 1
+moin    = 15
+noff    = 2.4
+voffcv  = -0.16
+tvoff   = 0.0032
+ltvoff  = 0
+wtvoff  = 0
+ptvoff  = 0
+kt1     = -0.29666254
+lkt1    = -7.8484113e-009
+wkt1    = -3.0126506e-008
+pkt1    = 4.0086707e-015
+kt1l    = 0
+kt2     = -0.02066331
+lkt2    = 2.0360792e-009
+wkt2    = 9.344692e-009
+pkt2    = -2.5043775e-015
+ute     = -1
+ua1     = 1.7983391e-009
+lua1    = -1.4558948e-016
+wua1    = -2.0835087e-017
+pua1    = 1.0167522e-023
+ub1     = -2.5953331e-018
+lub1    = -1.2006485e-025
+wub1    = -1.0700731e-025
+pub1    = -6.1005134e-032
+uc1     = -8.5716307e-011
+luc1    = 8.3755803e-019
+wuc1    = 1.7214564e-017
+puc1    = -8.400707e-024
+prt     = 0
+at      = 12000
+fnoimod = 1
+tnoimod = 0
+em      = 4.1e+007
+ef      = 1.12
+noia    = pmos_3p3_noia
+noib    = pmos_3p3_noib
+noic    = pmos_3p3_noic
+ntnoi   = 1
+jss     = 1.653e-007
+jsws    = 2.1207e-013
+jswgs   = 0
+njs     = 1
+ijthsfwd= 0.1
+ijthsrev= 0.1
+jtss    = 1e-011
+jtssws  = 1e-011
+jtsswgs = 1e-011
+njts    = 20
+njtssw  = 20
+njtsswg = 20
+vtss    = 10
+vtssws  = 10
+vtsswgs = 10
+pbs     = 0.69939
+cjs     = 0.00094344
+mjs     = 0.32084
+pbsws   = 0.8022
+cjsws   = 1.5078e-010
+mjsws   = 0.05
+pbswgs  = 0.65
+cjswgs  = 4.794e-010
+mjswgs  = 0.21964
+tpb     = 0.0016906
+tcj     = 0.00099187
+tpbsw   = 0.0052
+tcjsw   = 0.00063483
+tpbswg  = 0.000744
+tcjswg  = 0.000932
+xtis    = 3
+dmcg    = 1.5e-007
+saref   = 4.4e-007
+sbref   = 4.4e-007
+kvth0   = 0
+ku0     = 0
+kvsat   = 0

.model  pmos_3p3.9  pmos
+level = 54
+lmin    = 5e-007
+lmax    = 1.2e-006
+wmin    = 1.2e-006
+wmax    = 1e-005
+version = 4.5
+binunit = 2
+paramchk= 1
+mobmod  = 0
+capmod  = 2
+igcmod  = 0
+igbmod  = 0
+geomod  = 0
+diomod  = 1
+rdsmod  = 0
+rbodymod= 0
+rgatemod= 0
+permod  = 1
+acnqsmod= 0
+trnqsmod= 0
+tnom    = 25
+toxe    = 7.5e-009
+toxp    = 7.5e-009
+toxm    = 7.9e-009
+epsrox  = 3.9
+wint    = -1e-008
+lint    = 0
+ll      = 0
+wl      = 0
+lln     = 1
+wln     = 1
+lw      = 0
+ww      = 0
+lwn     = 1
+wwn     = 1
+lwl     = 0
+wwl     = 0
+xl      = -1.2e-008
+xw      = 1e-008
+dlc     = -8e-009
+dwc     = 0
+xpart   = 0
+toxref  = 7.9e-009
+dlcig   = 1.5e-007
+vth0    = -0.69065918
+lvth0   = -6.9145954e-009
+wvth0   = -8.8655847e-009
+pvth0   = 1.3863278e-014
+k1      = 0.976558
+lk1     = -2.3769504e-008
+k2      = -0.030611931
+lk2     = -2.6591455e-009
+wk2     = 6.1836949e-009
+pk2     = -3.0176431e-015
+k3      = 0
+k3b     = 0
+w0      = 2.5e-006
+dvt0    = 2.8985
+dvt1    = 0.23999
+dvt2    = -0.016
+dvt0w   = 0
+dvt1w   = 5300000
+dvt2w   = -0.032
+dsub    = 0.3659
+minv    = -0.1
+voffl   = 0
+dvtp0   = 0
+dvtp1   = 0
+lpe0    = 3.2493e-008
+lpeb    = 0
+vbm     = -3
+xj      = 1e-007
+ngate   = 6e+019
+ndep    = 5.6e+017
+nsd     = 1e+020
+phin    = 0
+cdsc    = 0.00024
+cdscb   = 0
+cdscd   = 0
+cit     = 0
+voff    = -0.094293534
+lvoff   = -1.7409232e-009
+wvoff   = -3.578168e-008
+pvoff   = 1.746146e-014
+nfactor = 0.8
+eta0    = 0.2541
+etab    = -0.15284
+vfb     = 0
+u0      = 0.010175439
+lu0     = 2.3220281e-009
+wu0     = -4.5913295e-010
+pu0     = -1.301569e-015
+ua      = 3.3870848e-010
+lua     = 6.2016345e-016
+wua     = -6.2996698e-017
+pua     = -1.0403264e-022
+ub      = 9.6244193e-019
+lub     = 1.5271135e-026
+wub     = 8.8344941e-026
+pub     = -1.5316948e-031
+uc      = -2.6312627e-011
+luc     = 7.086732e-017
+wuc     = 2.4803882e-017
+puc     = -2.9467012e-023
+eu      = 1.67
+vsat    = 94000
+a0      = 1.1722707
+la0     = -2.8242886e-007
+wa0     = 1.4099098e-007
+pa0     = -1.0489184e-013
+ags     = 0.20910427
+lags    = 5.8655514e-008
+wags    = -6.2574519e-009
+pags    = 3.0536365e-015
+a1      = 0
+a2      = 0.99
+b0      = 0
+b1      = 0
+keta    = -0.0071507123
+lketa   = -2.2657878e-008
+wketa   = 2.1061652e-009
+pketa   = -2.5021242e-015
+dwg     = 0
+dwb     = 0
+pclm    = 0.37814802
+lpclm   = 2.3288533e-008
+wpclm   = 1.4532708e-007
+ppclm   = -2.9317233e-014
+pdiblc1 = 0.1484
+pdiblc2 = 0.00025119377
+lpdiblc2= 2.3704904e-010
+pdiblcb = 0
+drout   = 0.56
+pvag    = 0
+delta   = 0.01
+pscbe1  = 6.7448e+008
+pscbe2  = 1e-005
+fprout  = 0
+pdits   = 0
+pditsd  = 0
+pditsl  = 0
+rsh     = 7
+rdsw    = 466
+rdswmin = 20
+prwg    = 0
+prwb    = 0
+alpha0  = 0.00011002657
+lalpha0 = -5.1176698e-011
+walpha0 = -5.3214657e-012
+palpha0 = 2.9909383e-018
+alpha1  = 0
+beta0   = 43.086027
+lbeta0  = -4.8934045e-006
+wbeta0  = 3.9093553e-009
+pbeta0  = -4.6443141e-015
+agidl   = 1.5908e-011
+bgidl   = 1.3902e+009
+cgidl   = 7.5
+egidl   = 0.1009
+cgso    = 1.116e-010
+cgdo    = 1.116e-010
+cgbo    = 1e-013
+cgdl    = 3.6e-011
+cgsl    = 3.6e-011
+clc     = 1e-007
+cle     = 0.6
+cf      = 0
+ckappas = 0.6
+ckappad = 0.6
+vfbcv   = -1
+acde    = 1
+moin    = 15
+noff    = 2.4
+voffcv  = -0.16
+tvoff   = 0.0032
+ltvoff  = 0
+wtvoff  = 0
+ptvoff  = 0
+kt1     = -0.30282331
+lkt1    = -4.8419541e-009
+wkt1    = 3.5856399e-008
+pkt1    = -2.8190987e-014
+kt1l    = 0
+kt2     = -0.010678274
+lkt2    = -2.8366187e-009
+wkt2    = -2.9369032e-009
+pkt2    = 3.489041e-015
+ute     = -1
+ua1     = 1.5e-009
+ub1     = -2.4652457e-018
+lub1    = -1.8354751e-025
+wub1    = -3.9237991e-025
+pub1    = 7.8256693e-032
+uc1     = -3.52542e-011
+luc1    = -2.378795e-017
+wuc1    = -5.9957334e-017
+puc1    = 2.9259179e-023
+prt     = 0
+at      = 12000
+fnoimod = 1
+tnoimod = 0
+em      = 4.1e+007
+ef      = 1.12
+noia    = pmos_3p3_noia
+noib    = pmos_3p3_noib
+noic    = pmos_3p3_noic
+ntnoi   = 1
+jss     = 1.653e-007
+jsws    = 2.1207e-013
+jswgs   = 0
+njs     = 1
+ijthsfwd= 0.1
+ijthsrev= 0.1
+jtss    = 1e-011
+jtssws  = 1e-011
+jtsswgs = 1e-011
+njts    = 20
+njtssw  = 20
+njtsswg = 20
+vtss    = 10
+vtssws  = 10
+vtsswgs = 10
+pbs     = 0.69939
+cjs     = 0.00094344
+mjs     = 0.32084
+pbsws   = 0.8022
+cjsws   = 1.5078e-010
+mjsws   = 0.05
+pbswgs  = 0.65
+cjswgs  = 4.794e-010
+mjswgs  = 0.21964
+tpb     = 0.0016906
+tcj     = 0.00099187
+tpbsw   = 0.0052
+tcjsw   = 0.00063483
+tpbswg  = 0.000744
+tcjswg  = 0.000932
+xtis    = 3
+dmcg    = 1.5e-007
+saref   = 4.4e-007
+sbref   = 4.4e-007
+kvth0   = 0
+ku0     = 0
+kvsat   = 0

.model  pmos_3p3.10  pmos
+level = 54
+lmin    = 1.2e-006
+lmax    = 1e-005
+wmin    = 1.2e-006
+wmax    = 1e-005
+version = 4.5
+binunit = 2
+paramchk= 1
+mobmod  = 0
+capmod  = 2
+igcmod  = 0
+igbmod  = 0
+geomod  = 0
+diomod  = 1
+rdsmod  = 0
+rbodymod= 0
+rgatemod= 0
+permod  = 1
+acnqsmod= 0
+trnqsmod= 0
+tnom    = 25
+toxe    = 7.5e-009
+toxp    = 7.5e-009
+toxm    = 7.9e-009
+epsrox  = 3.9
+wint    = -1e-008
+lint    = 0
+ll      = 0
+wl      = 0
+lln     = 1
+wln     = 1
+lw      = 0
+ww      = 0
+lwn     = 1
+wwn     = 1
+lwl     = 0
+wwl     = 0
+xl      = -1.2e-008
+xw      = 1e-008
+dlc     = -8e-009
+dwc     = 0
+xpart   = 0
+toxref  = 7.9e-009
+dlcig   = 1.5e-007
+vth0    = -0.69275726
+lvth0   = -4.4220735e-009
+wvth0   = -3.7851852e-010
+pvth0   = 3.780643e-015
+k1      = 1.0136972
+lk1     = -6.7890933e-008
+k2      = -0.036022469
+lk2     = 3.7685735e-009
+wk2     = 3.995242e-009
+pk2     = -4.1776105e-016
+k3      = 0
+k3b     = 0
+w0      = 2.5e-006
+dvt0    = 2.8985
+dvt1    = 0.23999
+dvt2    = -0.016
+dvt0w   = 0
+dvt1w   = 5300000
+dvt2w   = -0.032
+dsub    = 0.3659
+minv    = -0.1
+voffl   = 0
+dvtp0   = 0
+dvtp1   = 0
+lpe0    = 3.2493e-008
+lpeb    = 0
+vbm     = -3
+xj      = 1e-007
+ngate   = 6e+019
+ndep    = 5.6e+017
+nsd     = 1e+020
+phin    = 0
+cdsc    = 0.00024
+cdscb   = 0
+cdscd   = 0
+cit     = 0
+voff    = -0.098144776
+lvoff   = 2.8343515e-009
+wvoff   = 2.84627e-009
+pvoff   = -2.8428545e-014
+nfactor = 0.8
+eta0    = 0.2541
+etab    = -0.15284
+vfb     = 0
+u0      = 0.01103441
+lu0     = 1.3015701e-009
+wu0     = -1.8930146e-009
+pu0     = 4.0188235e-016
+ua      = 6.6815328e-010
+lua     = 2.2878304e-016
+wua     = -3.8106455e-016
+pua     = 2.7383197e-022
+ub      = 9.7529642e-019
+wub     = -4.0585597e-026
+uc      = -1.6546655e-011
+luc     = 5.9265346e-017
+eu      = 1.67
+vsat    = 94000
+a0      = 1.1829466
+la0     = -2.9511192e-007
+wa0     = -7.1142556e-009
+pa0     = 7.1057185e-014
+ags     = 0.1669723
+lags    = 1.087083e-007
+wags    = -5.1509361e-009
+pags    = 1.7390958e-015
+a1      = 0
+a2      = 0.99
+b0      = 0
+b1      = 0
+keta    = -0.0068457125
+lketa   = -2.3020218e-008
+dwg     = 0
+dwb     = 0
+pclm    = 0.34321309
+lpclm   = 6.4791222e-008
+wpclm   = -1.6287652e-008
+ppclm   = 1.6268107e-013
+pdiblc1 = 0.1484
+pdiblc2 = 7.88813e-005
+lpdiblc2= 4.4175626e-010
+pdiblcb = 0
+drout   = 0.56
+pvag    = 0
+delta   = 0.01
+pscbe1  = 6.7448e+008
+pscbe2  = 1e-005
+fprout  = 0
+pdits   = 0
+pditsd  = 0
+pditsl  = 0
+rsh     = 7
+rdsw    = 466
+rdswmin = 20
+prwg    = 0
+prwb    = 0
+alpha0  = 0.002140198
+lalpha0 = -2.4630203e-009
+walpha0 = 3.7851852e-013
+palpha0 = -3.780643e-018
+alpha1  = 0
+beta0   = 44.155152
+lbeta0  = -6.1635247e-006
+wbeta0  = 6.9375436e-007
+pbeta0  = -8.2418018e-013
+agidl   = 1.5908e-011
+bgidl   = 1.3902e+009
+cgidl   = 7.5
+egidl   = 0.1009
+cgso    = 1.116e-010
+cgdo    = 1.116e-010
+cgbo    = 1e-013
+cgdl    = 3.6e-011
+cgsl    = 3.6e-011
+clc     = 1e-007
+cle     = 0.6
+cf      = 0
+ckappas = 0.6
+ckappad = 0.6
+vfbcv   = -1
+acde    = 1
+moin    = 15
+noff    = 1.946
+lnoff   = 5.39352e-007
+voffcv  = 0.0216
+lvoffcv = -2.157408e-007
+tvoff   = 0.0032
+ltvoff  = 0
+wtvoff  = 0
+ptvoff  = 0
+kt1     = -0.29670156
+lkt1    = -1.2114597e-008
+wkt1    = -2.4581904e-008
+pkt1    = 4.3609717e-014
+kt1l    = 0
+kt2     = -0.012755062
+lkt2    = -3.6939483e-010
+wkt2    = -3.1187122e-009
+pkt2    = 3.7050301e-015
+ute     = -1
+ua1     = 1.3959912e-009
+lua1    = 1.2356248e-016
+wua1    = 1.2793085e-016
+pua1    = -1.5198185e-022
+ub1     = -2.6566947e-018
+lub1    = 4.3893906e-026
+wub1    = 4.4078482e-026
+pub1    = -4.4025588e-031
+uc1     = -6.6595019e-011
+luc1    = 1.3444942e-017
+wuc1    = 2.0808425e-017
+puc1    = -6.6690543e-023
+prt     = 0
+at      = 12000
+fnoimod = 1
+tnoimod = 0
+em      = 4.1e+007
+ef      = 1.12
+noia    = pmos_3p3_noia
+noib    = pmos_3p3_noib
+noic    = pmos_3p3_noic
+ntnoi   = 1
+jss     = 1.653e-007
+jsws    = 2.1207e-013
+jswgs   = 0
+njs     = 1
+ijthsfwd= 0.1
+ijthsrev= 0.1
+jtss    = 1e-011
+jtssws  = 1e-011
+jtsswgs = 1e-011
+njts    = 20
+njtssw  = 20
+njtsswg = 20
+vtss    = 10
+vtssws  = 10
+vtsswgs = 10
+pbs     = 0.69939
+cjs     = 0.00094344
+mjs     = 0.32084
+pbsws   = 0.8022
+cjsws   = 1.5078e-010
+mjsws   = 0.05
+pbswgs  = 0.65
+cjswgs  = 4.794e-010
+mjswgs  = 0.21964
+tpb     = 0.0016906
+tcj     = 0.00099187
+tpbsw   = 0.0052
+tcjsw   = 0.00063483
+tpbswg  = 0.000744
+tcjswg  = 0.000932
+xtis    = 3
+dmcg    = 1.5e-007
+saref   = 4.4e-007
+sbref   = 4.4e-007
+kvth0   = 0
+ku0     = 0
+kvsat   = 0

.model  pmos_3p3.11  pmos
+level = 54
+lmin    = 1e-005
+lmax    = 5.0001e-005
+wmin    = 1.2e-006
+wmax    = 1e-005
+version = 4.5
+binunit = 2
+paramchk= 1
+mobmod  = 0
+capmod  = 2
+igcmod  = 0
+igbmod  = 0
+geomod  = 0
+diomod  = 1
+rdsmod  = 0
+rbodymod= 0
+rgatemod= 0
+permod  = 1
+acnqsmod= 0
+trnqsmod= 0
+tnom    = 25
+toxe    = 7.5e-009
+toxp    = 7.5e-009
+toxm    = 7.9e-009
+epsrox  = 3.9
+wint    = -1e-008
+lint    = 0
+ll      = 0
+wl      = 0
+lln     = 1
+wln     = 1
+lw      = 0
+ww      = 0
+lwn     = 1
+wwn     = 1
+lwl     = 0
+wwl     = 0
+xl      = -1.2e-008
+xw      = 1e-008
+dlc     = -8e-009
+dwc     = 0
+xpart   = 0
+toxref  = 7.9e-009
+dlcig   = 1.5e-007
+vth0    = -0.6932
+k1      = 1.0069
+k2      = -0.035645159
+wk2     = 3.9534157e-009
+k3      = 0
+k3b     = 0
+w0      = 2.5e-006
+dvt0    = 2.8985
+dvt1    = 0.23999
+dvt2    = -0.016
+dvt0w   = 0
+dvt1w   = 5300000
+dvt2w   = -0.032
+dsub    = 0.3659
+minv    = -0.1
+voffl   = 0
+dvtp0   = 0
+dvtp1   = 0
+lpe0    = 3.2493e-008
+lpeb    = 0
+vbm     = -3
+xj      = 1e-007
+ngate   = 6e+019
+ndep    = 5.6e+017
+nsd     = 1e+020
+phin    = 0
+cdsc    = 0.00024
+cdscb   = 0
+cdscd   = 0
+cit     = 0
+voff    = -0.097861
+nfactor = 0.8
+eta0    = 0.2541
+etab    = -0.15284
+vfb     = 0
+u0      = 0.011164724
+wu0     = -1.8527781e-009
+ua      = 6.9105907e-010
+wua     = -3.5364845e-016
+ub      = 9.7529642e-019
+wub     = -4.0585597e-026
+uc      = -1.0613e-011
+eu      = 1.67
+vsat    = 94000
+a0      = 1.1534
+ags     = 0.17785619
+wags    = -4.9768176e-009
+a1      = 0
+a2      = 0.99
+b0      = 0
+b1      = 0
+keta    = -0.0091505
+dwg     = 0
+dwb     = 0
+pclm    = 0.3497
+pdiblc1 = 0.1484
+pdiblc2 = 0.00012311
+pdiblcb = 0
+drout   = 0.56
+pvag    = 0
+delta   = 0.01
+pscbe1  = 6.7448e+008
+pscbe2  = 1e-005
+fprout  = 0
+pdits   = 0
+pditsd  = 0
+pditsl  = 0
+rsh     = 7
+rdsw    = 466
+rdswmin = 20
+prwg    = 0
+prwb    = 0
+alpha0  = 0.0018936
+alpha1  = 0
+beta0   = 43.538059
+wbeta0  = 6.1123732e-007
+agidl   = 1.5908e-011
+bgidl   = 1.3902e+009
+cgidl   = 7.5
+egidl   = 0.1009
+cgso    = 1.116e-010
+cgdo    = 1.116e-010
+cgbo    = 1e-013
+cgdl    = 3.6e-011
+cgsl    = 3.6e-011
+clc     = 1e-007
+cle     = 0.6
+cf      = 0
+ckappas = 0.6
+ckappad = 0.6
+vfbcv   = -1
+acde    = 1
+moin    = 15
+noff    = 2
+voffcv  = 0
+tvoff   = 0.0032
+ltvoff  = 0
+wtvoff  = 0
+ptvoff  = 0
+kt1     = -0.29791448
+wkt1    = -2.0215693e-008
+kt1l    = 0
+kt2     = -0.012792045
+wkt2    = -2.7477641e-009
+ute     = -1
+ua1     = 1.4083623e-009
+wua1    = 1.1271441e-016
+ub1     = -2.6523e-018
+uc1     = -6.5248909e-011
+wuc1    = 1.4131358e-017
+prt     = 0
+at      = 12000
+fnoimod = 1
+tnoimod = 0
+em      = 4.1e+007
+ef      = 1.12
+noia    = pmos_3p3_noia
+noib    = pmos_3p3_noib
+noic    = pmos_3p3_noic
+ntnoi   = 1
+jss     = 1.653e-007
+jsws    = 2.1207e-013
+jswgs   = 0
+njs     = 1
+ijthsfwd= 0.1
+ijthsrev= 0.1
+jtss    = 1e-011
+jtssws  = 1e-011
+jtsswgs = 1e-011
+njts    = 20
+njtssw  = 20
+njtsswg = 20
+vtss    = 10
+vtssws  = 10
+vtsswgs = 10
+pbs     = 0.69939
+cjs     = 0.00094344
+mjs     = 0.32084
+pbsws   = 0.8022
+cjsws   = 1.5078e-010
+mjsws   = 0.05
+pbswgs  = 0.65
+cjswgs  = 4.794e-010
+mjswgs  = 0.21964
+tpb     = 0.0016906
+tcj     = 0.00099187
+tpbsw   = 0.0052
+tcjsw   = 0.00063483
+tpbswg  = 0.000744
+tcjswg  = 0.000932
+xtis    = 3
+dmcg    = 1.5e-007
+saref   = 4.4e-007
+sbref   = 4.4e-007
+kvth0   = 0
+ku0     = 0
+kvsat   = 0

.model  pmos_3p3.12  pmos
+level = 54
+lmin    = 2.8e-007
+lmax    = 5e-007
+wmin    = 1e-005
+wmax    = 0.000100001
+version = 4.5
+binunit = 2
+paramchk= 1
+mobmod  = 0
+capmod  = 2
+igcmod  = 0
+igbmod  = 0
+geomod  = 0
+diomod  = 1
+rdsmod  = 0
+rbodymod= 0
+rgatemod= 0
+permod  = 1
+acnqsmod= 0
+trnqsmod= 0
+tnom    = 25
+toxe    = 7.5e-009
+toxp    = 7.5e-009
+toxm    = 7.9e-009
+epsrox  = 3.9
+wint    = -1e-008
+lint    = 0
+ll      = 0
+wl      = 0
+lln     = 1
+wln     = 1
+lw      = 0
+ww      = 0
+lwn     = 1
+wwn     = 1
+lwl     = 0
+wwl     = 0
+xl      = -1.2e-008
+xw      = 1e-008
+dlc     = -8e-009
+dwc     = 0
+xpart   = 0
+toxref  = 7.9e-009
+dlcig   = 1.5e-007
+vth0    = -0.68753091
+lvth0   = -7.4903564e-009
+k1      = 0.99566618
+lk1     = -3.3094297e-008
+k2      = -0.0017606545
+lk2     = -1.6738569e-008
+k3      = 0
+k3b     = 0
+w0      = 2.5e-006
+dvt0    = 2.8985
+dvt1    = 0.23999
+dvt2    = -0.016
+dvt0w   = 0
+dvt1w   = 5300000
+dvt2w   = -0.032
+dsub    = 0.3659
+minv    = -0.1
+voffl   = 0
+dvtp0   = 0
+dvtp1   = 0
+lpe0    = 3.2493e-008
+lpeb    = 0
+vbm     = -3
+xj      = 1e-007
+ngate   = 6e+019
+ndep    = 5.6e+017
+nsd     = 1e+020
+phin    = 0
+cdsc    = 0.00024
+cdscb   = 0
+cdscd   = 0
+cit     = 0
+voff    = -0.097861
+nfactor = 0.8
+eta0    = 0.2541
+etab    = -0.15284
+vfb     = 0
+u0      = 0.011225709
+lu0     = 1.65739e-009
+ua      = 3.5504727e-010
+lua     = 5.9875293e-016
+ub      = 9.7125e-019
+uc      = 1.26214e-010
+luc     = -5.296752e-018
+eu      = 1.67
+vsat    = 94000
+a0      = 0.86832964
+la0     = -1.3770366e-007
+ags     = 0.31597309
+lags    = 6.5035316e-009
+a1      = 0
+a2      = 0.99
+b0      = 0
+b1      = 0
+keta    = -0.088067836
+lketa   = 1.6682688e-008
+dwg     = 0
+dwb     = 0
+pclm    = 0.33743927
+lpclm   = 4.7302195e-008
+pdiblc1 = 0.1484
+pdiblc2 = 0.00073695
+pdiblcb = 0
+drout   = 0.56
+pvag    = 0
+delta   = 0.01
+pscbe1  = 6.7448e+008
+pscbe2  = 1e-005
+fprout  = 0
+pdits   = 0
+pditsd  = 0
+pditsl  = 0
+rsh     = 7
+rdsw    = 466
+rdswmin = 20
+prwg    = 0
+prwb    = 0
+alpha0  = 9.7661218e-006
+lalpha0 = -2.2103091e-012
+alpha1  = 0
+beta0   = 37.749218
+lbeta0  = -2.2893145e-006
+agidl   = 1.5908e-011
+bgidl   = 1.3902e+009
+cgidl   = 7.5
+egidl   = 0.1009
+cgso    = 1.116e-010
+cgdo    = 1.116e-010
+cgbo    = 1e-013
+cgdl    = 3.6e-011
+cgsl    = 3.6e-011
+clc     = 1e-007
+cle     = 0.6
+cf      = 0
+ckappas = 0.6
+ckappad = 0.6
+vfbcv   = -1
+acde    = 1
+moin    = 15
+noff    = 2.4
+voffcv  = -0.16
+tvoff   = 0.0032
+ltvoff  = 0
+wtvoff  = 0
+ptvoff  = 0
+kt1     = -0.29966618
+lkt1    = -7.4487433e-009
+kt1l    = 0
+kt2     = -0.019731636
+lkt2    = 1.7863906e-009
+ute     = -1
+ua1     = 1.7962618e-009
+lua1    = -1.4457577e-016
+ub1     = -2.6060018e-018
+lub1    = -1.2614711e-025
+uc1     = -8.4e-011
+prt     = 0
+at      = 12000
+fnoimod = 1
+tnoimod = 0
+em      = 4.1e+007
+ef      = 1.12
+noia    = pmos_3p3_noia
+noib    = pmos_3p3_noib
+noic    = pmos_3p3_noic
+ntnoi   = 1
+jss     = 1.653e-007
+jsws    = 2.1207e-013
+jswgs   = 0
+njs     = 1
+ijthsfwd= 0.1
+ijthsrev= 0.1
+jtss    = 1e-011
+jtssws  = 1e-011
+jtsswgs = 1e-011
+njts    = 20
+njtssw  = 20
+njtsswg = 20
+vtss    = 10
+vtssws  = 10
+vtsswgs = 10
+pbs     = 0.69939
+cjs     = 0.00094344
+mjs     = 0.32084
+pbsws   = 0.8022
+cjsws   = 1.5078e-010
+mjsws   = 0.05
+pbswgs  = 0.65
+cjswgs  = 4.794e-010
+mjswgs  = 0.21964
+tpb     = 0.0016906
+tcj     = 0.00099187
+tpbsw   = 0.0052
+tcjsw   = 0.00063483
+tpbswg  = 0.000744
+tcjswg  = 0.000932
+xtis    = 3
+dmcg    = 1.5e-007
+saref   = 4.4e-007
+sbref   = 4.4e-007
+kvth0   = 0
+ku0     = 0
+kvsat   = 0

.model  pmos_3p3.13  pmos
+level = 54
+lmin    = 5e-007
+lmax    = 1.2e-006
+wmin    = 1e-005
+wmax    = 0.000100001
+version = 4.5
+binunit = 2
+paramchk= 1
+mobmod  = 0
+capmod  = 2
+igcmod  = 0
+igbmod  = 0
+geomod  = 0
+diomod  = 1
+rdsmod  = 0
+rbodymod= 0
+rgatemod= 0
+permod  = 1
+acnqsmod= 0
+trnqsmod= 0
+tnom    = 25
+toxe    = 7.5e-009
+toxp    = 7.5e-009
+toxm    = 7.9e-009
+epsrox  = 3.9
+wint    = -1e-008
+lint    = 0
+ll      = 0
+wl      = 0
+lln     = 1
+wln     = 1
+lw      = 0
+ww      = 0
+lwn     = 1
+wwn     = 1
+lwl     = 0
+wwl     = 0
+xl      = -1.2e-008
+xw      = 1e-008
+dlc     = -8e-009
+dwc     = 0
+xpart   = 0
+toxref  = 7.9e-009
+dlcig   = 1.5e-007
+vth0    = -0.69154309
+lvth0   = -5.5324142e-009
+k1      = 0.976558
+lk1     = -2.3769504e-008
+k2      = -0.029995411
+lk2     = -2.9600072e-009
+k3      = 0
+k3b     = 0
+w0      = 2.5e-006
+dvt0    = 2.8985
+dvt1    = 0.23999
+dvt2    = -0.016
+dvt0w   = 0
+dvt1w   = 5300000
+dvt2w   = -0.032
+dsub    = 0.3659
+minv    = -0.1
+voffl   = 0
+dvtp0   = 0
+dvtp1   = 0
+lpe0    = 3.2493e-008
+lpeb    = 0
+vbm     = -3
+xj      = 1e-007
+ngate   = 6e+019
+ndep    = 5.6e+017
+nsd     = 1e+020
+phin    = 0
+cdsc    = 0.00024
+cdscb   = 0
+cdscd   = 0
+cit     = 0
+voff    = -0.097861
+nfactor = 0.8
+eta0    = 0.2541
+etab    = -0.15284
+vfb     = 0
+u0      = 0.010129663
+lu0     = 2.1922605e-009
+ua      = 3.3242766e-010
+lua     = 6.097913e-016
+ub      = 9.7125e-019
+uc      = -2.3839657e-011
+luc     = 6.7929433e-017
+eu      = 1.67
+vsat    = 94000
+a0      = 1.1863276
+la0     = -2.9288667e-007
+ags     = 0.2084804
+lags    = 5.8959965e-008
+a1      = 0
+a2      = 0.99
+b0      = 0
+b1      = 0
+keta    = -0.0069407257
+lketa   = -2.2907342e-008
+dwg     = 0
+dwb     = 0
+pclm    = 0.39263726
+lpclm   = 2.0365578e-008
+pdiblc1 = 0.1484
+pdiblc2 = 0.00025119377
+lpdiblc2= 2.3704904e-010
+pdiblcb = 0
+drout   = 0.56
+pvag    = 0
+delta   = 0.01
+pscbe1  = 6.7448e+008
+pscbe2  = 1e-005
+fprout  = 0
+pdits   = 0
+pditsd  = 0
+pditsl  = 0
+rsh     = 7
+rdsw    = 466
+rdswmin = 20
+prwg    = 0
+prwb    = 0
+alpha0  = 0.00010949602
+lalpha0 = -5.0878499e-011
+alpha1  = 0
+beta0   = 43.086417
+lbeta0  = -4.8938676e-006
+agidl   = 1.5908e-011
+bgidl   = 1.3902e+009
+cgidl   = 7.5
+egidl   = 0.1009
+cgso    = 1.116e-010
+cgdo    = 1.116e-010
+cgbo    = 1e-013
+cgdl    = 3.6e-011
+cgsl    = 3.6e-011
+clc     = 1e-007
+cle     = 0.6
+cf      = 0
+ckappas = 0.6
+ckappad = 0.6
+vfbcv   = -1
+acde    = 1
+moin    = 15
+noff    = 2.4
+voffcv  = -0.16
+tvoff   = 0.0032
+ltvoff  = 0
+wtvoff  = 0
+ptvoff  = 0
+kt1     = -0.2992484
+lkt1    = -7.6526208e-009
+kt1l    = 0
+kt2     = -0.010971086
+lkt2    = -2.4887582e-009
+ute     = -1
+ua1     = 1.5e-009
+ub1     = -2.5043663e-018
+lub1    = -1.7574525e-025
+uc1     = -4.1232e-011
+luc1    = -2.0870784e-017
+prt     = 0
+at      = 12000
+fnoimod = 1
+tnoimod = 0
+em      = 4.1e+007
+ef      = 1.12
+noia    = pmos_3p3_noia
+noib    = pmos_3p3_noib
+noic    = pmos_3p3_noic
+ntnoi   = 1
+jss     = 1.653e-007
+jsws    = 2.1207e-013
+jswgs   = 0
+njs     = 1
+ijthsfwd= 0.1
+ijthsrev= 0.1
+jtss    = 1e-011
+jtssws  = 1e-011
+jtsswgs = 1e-011
+njts    = 20
+njtssw  = 20
+njtsswg = 20
+vtss    = 10
+vtssws  = 10
+vtsswgs = 10
+pbs     = 0.69939
+cjs     = 0.00094344
+mjs     = 0.32084
+pbsws   = 0.8022
+cjsws   = 1.5078e-010
+mjsws   = 0.05
+pbswgs  = 0.65
+cjswgs  = 4.794e-010
+mjswgs  = 0.21964
+tpb     = 0.0016906
+tcj     = 0.00099187
+tpbsw   = 0.0052
+tcjsw   = 0.00063483
+tpbswg  = 0.000744
+tcjswg  = 0.000932
+xtis    = 3
+dmcg    = 1.5e-007
+saref   = 4.4e-007
+sbref   = 4.4e-007
+kvth0   = 0
+ku0     = 0
+kvsat   = 0

.model  pmos_3p3.14  pmos
+level = 54
+lmin    = 1.2e-006
+lmax    = 1e-005
+wmin    = 1e-005
+wmax    = 0.000100001
+version = 4.5
+binunit = 2
+paramchk= 1
+mobmod  = 0
+capmod  = 2
+igcmod  = 0
+igbmod  = 0
+geomod  = 0
+diomod  = 1
+rdsmod  = 0
+rbodymod= 0
+rgatemod= 0
+permod  = 1
+acnqsmod= 0
+trnqsmod= 0
+tnom    = 25
+toxe    = 7.5e-009
+toxp    = 7.5e-009
+toxm    = 7.9e-009
+epsrox  = 3.9
+wint    = -1e-008
+lint    = 0
+ll      = 0
+wl      = 0
+lln     = 1
+wln     = 1
+lw      = 0
+ww      = 0
+lwn     = 1
+wwn     = 1
+lwl     = 0
+wwl     = 0
+xl      = -1.2e-008
+xw      = 1e-008
+dlc     = -8e-009
+dwc     = 0
+xpart   = 0
+toxref  = 7.9e-009
+dlcig   = 1.5e-007
+vth0    = -0.692795
+lvth0   = -4.04514e-009
+k1      = 1.0136972
+lk1     = -6.7890933e-008
+k2      = -0.03562414
+lk2     = 3.7269223e-009
+k3      = 0
+k3b     = 0
+w0      = 2.5e-006
+dvt0    = 2.8985
+dvt1    = 0.23999
+dvt2    = -0.016
+dvt0w   = 0
+dvt1w   = 5300000
+dvt2w   = -0.032
+dsub    = 0.3659
+minv    = -0.1
+voffl   = 0
+dvtp0   = 0
+dvtp1   = 0
+lpe0    = 3.2493e-008
+lpeb    = 0
+vbm     = -3
+xj      = 1e-007
+ngate   = 6e+019
+ndep    = 5.6e+017
+nsd     = 1e+020
+phin    = 0
+cdsc    = 0.00024
+cdscb   = 0
+cdscd   = 0
+cit     = 0
+voff    = -0.097861
+nfactor = 0.8
+eta0    = 0.2541
+etab    = -0.15284
+vfb     = 0
+u0      = 0.010845675
+lu0     = 1.3416381e-009
+ua      = 6.301608e-010
+lua     = 2.5608433e-016
+ub      = 9.7125e-019
+uc      = -1.6546655e-011
+luc     = 5.9265346e-017
+eu      = 1.67
+vsat    = 94000
+a0      = 1.1822374
+la0     = -2.8802745e-007
+ags     = 0.16645875
+lags    = 1.0888169e-007
+a1      = 0
+a2      = 0.99
+b0      = 0
+b1      = 0
+keta    = -0.0068457125
+lketa   = -2.3020217e-008
+dwg     = 0
+dwb     = 0
+pclm    = 0.3415892
+lpclm   = 8.101067e-008
+pdiblc1 = 0.1484
+pdiblc2 = 7.88813e-005
+lpdiblc2= 4.4175626e-010
+pdiblcb = 0
+drout   = 0.56
+pvag    = 0
+delta   = 0.01
+pscbe1  = 6.7448e+008
+pscbe2  = 1e-005
+fprout  = 0
+pdits   = 0
+pditsd  = 0
+pditsl  = 0
+rsh     = 7
+rdsw    = 466
+rdswmin = 20
+prwg    = 0
+prwb    = 0
+alpha0  = 0.0021402357
+lalpha0 = -2.4633972e-009
+alpha1  = 0
+beta0   = 44.22432
+lbeta0  = -6.2456962e-006
+agidl   = 1.5908e-011
+bgidl   = 1.3902e+009
+cgidl   = 7.5
+egidl   = 0.1009
+cgso    = 1.116e-010
+cgdo    = 1.116e-010
+cgbo    = 1e-013
+cgdl    = 3.6e-011
+cgsl    = 3.6e-011
+clc     = 1e-007
+cle     = 0.6
+cf      = 0
+ckappas = 0.6
+ckappad = 0.6
+vfbcv   = -1
+acde    = 1
+moin    = 15
+noff    = 1.946
+lnoff   = 5.39352e-007
+voffcv  = 0.0216
+lvoffcv = -2.157408e-007
+tvoff   = 0.0032
+ltvoff  = 0
+wtvoff  = 0
+ptvoff  = 0
+kt1     = -0.2991524
+lkt1    = -7.7666688e-009
+kt1l    = 0
+kt2     = -0.013066
+ute     = -1
+ua1     = 1.408746e-009
+lua1    = 1.0840975e-016
+ub1     = -2.6523e-018
+uc1     = -6.45204e-011
+luc1    = 6.7958352e-018
+prt     = 0
+at      = 12000
+fnoimod = 1
+tnoimod = 0
+em      = 4.1e+007
+ef      = 1.12
+noia    = pmos_3p3_noia
+noib    = pmos_3p3_noib
+noic    = pmos_3p3_noic
+ntnoi   = 1
+jss     = 1.653e-007
+jsws    = 2.1207e-013
+jswgs   = 0
+njs     = 1
+ijthsfwd= 0.1
+ijthsrev= 0.1
+jtss    = 1e-011
+jtssws  = 1e-011
+jtsswgs = 1e-011
+njts    = 20
+njtssw  = 20
+njtsswg = 20
+vtss    = 10
+vtssws  = 10
+vtsswgs = 10
+pbs     = 0.69939
+cjs     = 0.00094344
+mjs     = 0.32084
+pbsws   = 0.8022
+cjsws   = 1.5078e-010
+mjsws   = 0.05
+pbswgs  = 0.65
+cjswgs  = 4.794e-010
+mjswgs  = 0.21964
+tpb     = 0.0016906
+tcj     = 0.00099187
+tpbsw   = 0.0052
+tcjsw   = 0.00063483
+tpbswg  = 0.000744
+tcjswg  = 0.000932
+xtis    = 3
+dmcg    = 1.5e-007
+saref   = 4.4e-007
+sbref   = 4.4e-007
+kvth0   = 0
+ku0     = 0
+kvsat   = 0

.model  pmos_3p3.15  pmos
+level = 54
+lmin    = 1e-005
+lmax    = 5.0001e-005
+wmin    = 1e-005
+wmax    = 0.000100001
+version = 4.5
+binunit = 2
+paramchk= 1
+mobmod  = 0
+capmod  = 2
+igcmod  = 0
+igbmod  = 0
+geomod  = 0
+diomod  = 1
+rdsmod  = 0
+rbodymod= 0
+rgatemod= 0
+permod  = 1
+acnqsmod= 0
+trnqsmod= 0
+tnom    = 25
+toxe    = 7.5e-009
+toxp    = 7.5e-009
+toxm    = 7.9e-009
+epsrox  = 3.9
+wint    = -1e-008
+lint    = 0
+ll      = 0
+wl      = 0
+lln     = 1
+wln     = 1
+lw      = 0
+ww      = 0
+lwn     = 1
+wwn     = 1
+lwl     = 0
+wwl     = 0
+xl      = -1.2e-008
+xw      = 1e-008
+dlc     = -8e-009
+dwc     = 0
+xpart   = 0
+toxref  = 7.9e-009
+dlcig   = 1.5e-007
+vth0    = -0.6932
+k1      = 1.0069
+k2      = -0.035251
+k3      = 0
+k3b     = 0
+w0      = 2.5e-006
+dvt0    = 2.8985
+dvt1    = 0.23999
+dvt2    = -0.016
+dvt0w   = 0
+dvt1w   = 5300000
+dvt2w   = -0.032
+dsub    = 0.3659
+minv    = -0.1
+voffl   = 0
+dvtp0   = 0
+dvtp1   = 0
+lpe0    = 3.2493e-008
+lpeb    = 0
+vbm     = -3
+xj      = 1e-007
+ngate   = 6e+019
+ndep    = 5.6e+017
+nsd     = 1e+020
+phin    = 0
+cdsc    = 0.00024
+cdscb   = 0
+cdscd   = 0
+cit     = 0
+voff    = -0.097861
+nfactor = 0.8
+eta0    = 0.2541
+etab    = -0.15284
+vfb     = 0
+u0      = 0.01098
+ua      = 6.558e-010
+ub      = 9.7125e-019
+uc      = -1.0613e-011
+eu      = 1.67
+vsat    = 94000
+a0      = 1.1534
+ags     = 0.17736
+a1      = 0
+a2      = 0.99
+b0      = 0
+b1      = 0
+keta    = -0.0091505
+dwg     = 0
+dwb     = 0
+pclm    = 0.3497
+pdiblc1 = 0.1484
+pdiblc2 = 0.00012311
+pdiblcb = 0
+drout   = 0.56
+pvag    = 0
+delta   = 0.01
+pscbe1  = 6.7448e+008
+pscbe2  = 1e-005
+fprout  = 0
+pdits   = 0
+pditsd  = 0
+pditsl  = 0
+rsh     = 7
+rdsw    = 466
+rdswmin = 20
+prwg    = 0
+prwb    = 0
+alpha0  = 0.0018936
+alpha1  = 0
+beta0   = 43.599
+agidl   = 1.5908e-011
+bgidl   = 1.3902e+009
+cgidl   = 7.5
+egidl   = 0.1009
+cgso    = 1.116e-010
+cgdo    = 1.116e-010
+cgbo    = 1e-013
+cgdl    = 3.6e-011
+cgsl    = 3.6e-011
+clc     = 1e-007
+cle     = 0.6
+cf      = 0
+ckappas = 0.6
+ckappad = 0.6
+vfbcv   = -1
+acde    = 1
+moin    = 15
+noff    = 2
+voffcv  = 0
+tvoff   = 0.0032
+ltvoff  = 0
+wtvoff  = 0
+ptvoff  = 0
+kt1     = -0.29993
+kt1l    = 0
+kt2     = -0.013066
+ute     = -1
+ua1     = 1.4196e-009
+ub1     = -2.6523e-018
+uc1     = -6.384e-011
+prt     = 0
+at      = 12000
+fnoimod = 1
+tnoimod = 0
+em      = 4.1e+007
+ef      = 1.12
+noia    = pmos_3p3_noia
+noib    = pmos_3p3_noib
+noic    = pmos_3p3_noic
+ntnoi   = 1
+jss     = 1.653e-007
+jsws    = 2.1207e-013
+jswgs   = 0
+njs     = 1
+ijthsfwd= 0.1
+ijthsrev= 0.1
+jtss    = 1e-011
+jtssws  = 1e-011
+jtsswgs = 1e-011
+njts    = 20
+njtssw  = 20
+njtsswg = 20
+vtss    = 10
+vtssws  = 10
+vtsswgs = 10
+pbs     = 0.69939
+cjs     = 0.00094344
+mjs     = 0.32084
+pbsws   = 0.8022
+cjsws   = 1.5078e-010
+mjsws   = 0.05
+pbswgs  = 0.65
+cjswgs  = 4.794e-010
+mjswgs  = 0.21964
+tpb     = 0.0016906
+tcj     = 0.00099187
+tpbsw   = 0.0052
+tcjsw   = 0.00063483
+tpbswg  = 0.000744
+tcjswg  = 0.000932
+xtis    = 3
+dmcg    = 1.5e-007
+saref   = 4.4e-007
+sbref   = 4.4e-007
+kvth0   = 0
+ku0     = 0
+kvsat   = 0
